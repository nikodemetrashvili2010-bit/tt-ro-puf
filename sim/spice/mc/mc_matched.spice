* SILICON Monte Carlo v2: matched oscillator, mismatch-only common draws
* auto-generated by gen_mc_deck.py; see that file's header for the method
.lib /home/pc/pdks/sky130A/libs.tech/ngspice/sky130.lib.spice tt
.param MC_MM_SWITCH=1
.param MC_PR_SWITCH=0
.include /home/pc/pdks/sky130A/libs.ref/sky130_fd_sc_hd/spice/sky130_fd_sc_hd.spice
.param SUPPLY=1.8
Vdd VPWR 0 {SUPPLY}
Ven EN 0 PULSE(0 1.8 2n 50p 50p 1 2)

* --- the matched oscillator (macro layout parasitics) ---
X0_dlyin  EN 0 0 VPWR VPWR m0_net1 sky130_fd_sc_hd__clkdlybuf4s25_1
X0_nand   m0_net1 m0_n30 0 0 VPWR VPWR m0_n0 sky130_fd_sc_hd__nand2_1
X0_inv1 m0_n0 0 0 VPWR VPWR m0_n1 sky130_fd_sc_hd__inv_1
X0_inv2 m0_n1 0 0 VPWR VPWR m0_n2 sky130_fd_sc_hd__inv_1
X0_inv3 m0_n2 0 0 VPWR VPWR m0_n3 sky130_fd_sc_hd__inv_1
X0_inv4 m0_n3 0 0 VPWR VPWR m0_n4 sky130_fd_sc_hd__inv_1
X0_inv5 m0_n4 0 0 VPWR VPWR m0_n5 sky130_fd_sc_hd__inv_1
X0_inv6 m0_n5 0 0 VPWR VPWR m0_n6 sky130_fd_sc_hd__inv_1
X0_inv7 m0_n6 0 0 VPWR VPWR m0_n7 sky130_fd_sc_hd__inv_1
X0_inv8 m0_n7 0 0 VPWR VPWR m0_n8 sky130_fd_sc_hd__inv_1
X0_inv9 m0_n8 0 0 VPWR VPWR m0_n9 sky130_fd_sc_hd__inv_1
X0_inv10 m0_n9 0 0 VPWR VPWR m0_n10 sky130_fd_sc_hd__inv_1
X0_inv11 m0_n10 0 0 VPWR VPWR m0_n11 sky130_fd_sc_hd__inv_1
X0_inv12 m0_n11 0 0 VPWR VPWR m0_n12 sky130_fd_sc_hd__inv_1
X0_inv13 m0_n12 0 0 VPWR VPWR m0_n13 sky130_fd_sc_hd__inv_1
X0_inv14 m0_n13 0 0 VPWR VPWR m0_n14 sky130_fd_sc_hd__inv_1
X0_inv15 m0_n14 0 0 VPWR VPWR m0_n15 sky130_fd_sc_hd__inv_1
X0_inv16 m0_n15 0 0 VPWR VPWR m0_n16 sky130_fd_sc_hd__inv_1
X0_inv17 m0_n16 0 0 VPWR VPWR m0_n17 sky130_fd_sc_hd__inv_1
X0_inv18 m0_n17 0 0 VPWR VPWR m0_n18 sky130_fd_sc_hd__inv_1
X0_inv19 m0_n18 0 0 VPWR VPWR m0_n19 sky130_fd_sc_hd__inv_1
X0_inv20 m0_n19 0 0 VPWR VPWR m0_n20 sky130_fd_sc_hd__inv_1
X0_inv21 m0_n20 0 0 VPWR VPWR m0_n21 sky130_fd_sc_hd__inv_1
X0_inv22 m0_n21 0 0 VPWR VPWR m0_n22 sky130_fd_sc_hd__inv_1
X0_inv23 m0_n22 0 0 VPWR VPWR m0_n23 sky130_fd_sc_hd__inv_1
X0_inv24 m0_n23 0 0 VPWR VPWR m0_n24 sky130_fd_sc_hd__inv_1
X0_inv25 m0_n24 0 0 VPWR VPWR m0_n25 sky130_fd_sc_hd__inv_1
X0_inv26 m0_n25 0 0 VPWR VPWR m0_n26 sky130_fd_sc_hd__inv_1
X0_inv27 m0_n26 0 0 VPWR VPWR m0_n27 sky130_fd_sc_hd__inv_1
X0_inv28 m0_n27 0 0 VPWR VPWR m0_n28 sky130_fd_sc_hd__inv_1
X0_inv29 m0_n28 0 0 VPWR VPWR m0_n29 sky130_fd_sc_hd__inv_1
X0_inv30 m0_n29 0 0 VPWR VPWR m0_n30 sky130_fd_sc_hd__inv_1
X0_buf    m0_n15 0 0 VPWR VPWR m0_net2 sky130_fd_sc_hd__buf_1
X0_dlyout m0_net2 0 0 VPWR VPWR m0_out sky130_fd_sc_hd__clkdlybuf4s25_1
C0_n0 m0_n0 0 3.068490e-16
C0_n1 m0_n1 0 2.255910e-16
C0_n2 m0_n2 0 1.067930e-16
C0_n3 m0_n3 0 6.592350e-16
C0_n4 m0_n4 0 4.933900e-16
C0_n5 m0_n5 0 2.255700e-16
C0_n6 m0_n6 0 5.757220e-16
C0_n7 m0_n7 0 5.002390e-16
C0_n8 m0_n8 0 1.628300e-16
C0_n9 m0_n9 0 3.187680e-16
C0_n10 m0_n10 0 1.067930e-16
C0_n11 m0_n11 0 1.067930e-16
C0_n12 m0_n12 0 1.233470e-16
C0_n13 m0_n13 0 1.067930e-16
C0_n14 m0_n14 0 1.231760e-16
C0_n15 m0_n15 0 5.925330e-16
C0_n16 m0_n16 0 2.188230e-16
C0_n17 m0_n17 0 5.031700e-16
C0_n18 m0_n18 0 7.865940e-16
C0_n19 m0_n19 0 6.291400e-16
C0_n20 m0_n20 0 1.820890e-16
C0_n21 m0_n21 0 4.232880e-16
C0_n22 m0_n22 0 1.178430e-16
C0_n23 m0_n23 0 1.629830e-16
C0_n24 m0_n24 0 8.774660e-16
C0_n25 m0_n25 0 1.574940e-16
C0_n26 m0_n26 0 7.696420e-16
C0_n27 m0_n27 0 4.887020e-16
C0_n28 m0_n28 0 2.381970e-16
C0_n29 m0_n29 0 1.081190e-16
C0_n30 m0_n30 0 6.156450e-16
C0_net1 m0_net1 0 5.083940e-16
C0_net2 m0_net2 0 7.365850e-16
C0_out m0_out 0 1.942570e-15

.save v(m0_out)
.tran 5p 80n
.control
set rndseed=42
let mc_i = 0
dowhile mc_i < 40
  reset
  run
  meas tran tp0 TRIG v(m0_out) VAL=0.9 RISE=5 TARG v(m0_out) VAL=0.9 RISE=25
  let f0 = 20 / tp0
  print f0
  let mc_i = mc_i + 1
end
.endc
.end
