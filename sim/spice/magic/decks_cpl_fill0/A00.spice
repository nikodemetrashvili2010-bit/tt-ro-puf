* A00 coupled: lumped loads from a magic extraction
.lib "LIB" tt
.include "CELLS"
.param SUPPLY=1.8
Vdd VPWR 0 {SUPPLY}
Ven EN 0 PULSE(0 1.8 2n 50p 50p 1 2)
Xnand EN n30 0 0 VPWR VPWR n0 sky130_fd_sc_hd__nand2_1
Xi1 n0 0 0 VPWR VPWR n1 sky130_fd_sc_hd__inv_1
Xi2 n1 0 0 VPWR VPWR n2 sky130_fd_sc_hd__inv_1
Xi3 n2 0 0 VPWR VPWR n3 sky130_fd_sc_hd__inv_1
Xi4 n3 0 0 VPWR VPWR n4 sky130_fd_sc_hd__inv_1
Xi5 n4 0 0 VPWR VPWR n5 sky130_fd_sc_hd__inv_1
Xi6 n5 0 0 VPWR VPWR n6 sky130_fd_sc_hd__inv_1
Xi7 n6 0 0 VPWR VPWR n7 sky130_fd_sc_hd__inv_1
Xi8 n7 0 0 VPWR VPWR n8 sky130_fd_sc_hd__inv_1
Xi9 n8 0 0 VPWR VPWR n9 sky130_fd_sc_hd__inv_1
Xi10 n9 0 0 VPWR VPWR n10 sky130_fd_sc_hd__inv_1
Xi11 n10 0 0 VPWR VPWR n11 sky130_fd_sc_hd__inv_1
Xi12 n11 0 0 VPWR VPWR n12 sky130_fd_sc_hd__inv_1
Xi13 n12 0 0 VPWR VPWR n13 sky130_fd_sc_hd__inv_1
Xi14 n13 0 0 VPWR VPWR n14 sky130_fd_sc_hd__inv_1
Xi15 n14 0 0 VPWR VPWR n15 sky130_fd_sc_hd__inv_1
Xi16 n15 0 0 VPWR VPWR n16 sky130_fd_sc_hd__inv_1
Xi17 n16 0 0 VPWR VPWR n17 sky130_fd_sc_hd__inv_1
Xi18 n17 0 0 VPWR VPWR n18 sky130_fd_sc_hd__inv_1
Xi19 n18 0 0 VPWR VPWR n19 sky130_fd_sc_hd__inv_1
Xi20 n19 0 0 VPWR VPWR n20 sky130_fd_sc_hd__inv_1
Xi21 n20 0 0 VPWR VPWR n21 sky130_fd_sc_hd__inv_1
Xi22 n21 0 0 VPWR VPWR n22 sky130_fd_sc_hd__inv_1
Xi23 n22 0 0 VPWR VPWR n23 sky130_fd_sc_hd__inv_1
Xi24 n23 0 0 VPWR VPWR n24 sky130_fd_sc_hd__inv_1
Xi25 n24 0 0 VPWR VPWR n25 sky130_fd_sc_hd__inv_1
Xi26 n25 0 0 VPWR VPWR n26 sky130_fd_sc_hd__inv_1
Xi27 n26 0 0 VPWR VPWR n27 sky130_fd_sc_hd__inv_1
Xi28 n27 0 0 VPWR VPWR n28 sky130_fd_sc_hd__inv_1
Xi29 n28 0 0 VPWR VPWR n29 sky130_fd_sc_hd__inv_1
Xi30 n29 0 0 VPWR VPWR n30 sky130_fd_sc_hd__inv_1
Xbuf n15 0 0 VPWR VPWR out sky130_fd_sc_hd__buf_1
Cn0 n0 0 1.183637e-15
Cn1 n1 0 7.145963e-16
Cn2 n2 0 8.580144e-16
Cn3 n3 0 1.740220e-15
Cn4 n4 0 1.187108e-15
Cn5 n5 0 8.231993e-16
Cn6 n6 0 6.783510e-16
Cn7 n7 0 7.543189e-16
Cn8 n8 0 8.241017e-16
Cn9 n9 0 9.454710e-16
Cn10 n10 0 7.547942e-16
Cn11 n11 0 1.271667e-15
Cn12 n12 0 1.241665e-15
Cn13 n13 0 7.556854e-16
Cn14 n14 0 1.142383e-15
Cn15 n15 0 1.760116e-15
Cn16 n16 0 1.298895e-15
Cn17 n17 0 1.117043e-15
Cn18 n18 0 9.351602e-16
Cn19 n19 0 7.629377e-16
Cn20 n20 0 9.853284e-16
Cn21 n21 0 1.120585e-15
Cn22 n22 0 1.072132e-15
Cn23 n23 0 1.430733e-15
Cn24 n24 0 5.933557e-16
Cn25 n25 0 6.428356e-16
Cn26 n26 0 6.028070e-16
Cn27 n27 0 1.128166e-15
Cn28 n28 0 7.239870e-16
Cn29 n29 0 1.142545e-15
Cn30 n30 0 6.750733e-16
Cc0_1 n0 n1 5.725000e-17
Cc0_2 n0 n2 0.000000e+00
Cc0_4 n0 n4 0.000000e+00
Cc0_5 n0 n5 0.000000e+00
Cc0_9 n0 n9 0.000000e+00
Cc0_12 n0 n12 0.000000e+00
Cc0_27 n0 n27 0.000000e+00
Cc0_28 n0 n28 0.000000e+00
Cc0_29 n0 n29 0.000000e+00
Cc0_30 n0 n30 4.641000e-17
Cc1_2 n1 n2 4.434000e-17
Cc1_4 n1 n4 7.910000e-18
Cc1_5 n1 n5 0.000000e+00
Cc1_7 n1 n7 7.130000e-18
Cc1_8 n1 n8 1.180000e-18
Cc1_12 n1 n12 0.000000e+00
Cc1_27 n1 n27 0.000000e+00
Cc2_3 n2 n3 5.422000e-17
Cc2_4 n2 n4 6.184000e-17
Cc2_5 n2 n5 6.426000e-17
Cc2_6 n2 n6 1.180000e-18
Cc2_12 n2 n12 0.000000e+00
Cc3_4 n3 n4 6.815000e-17
Cc3_5 n3 n5 1.133000e-17
Cc3_6 n3 n6 3.093000e-17
Cc3_7 n3 n7 0.000000e+00
Cc3_8 n3 n8 0.000000e+00
Cc4_5 n4 n5 1.578200e-16
Cc4_6 n4 n6 3.711000e-17
Cc4_7 n4 n7 2.910000e-17
Cc4_8 n4 n8 1.770000e-18
Cc4_9 n4 n9 0.000000e+00
Cc5_6 n5 n6 1.000200e-16
Cc5_7 n5 n7 9.750000e-18
Cc5_8 n5 n8 0.000000e+00
Cc6_7 n6 n7 1.267800e-16
Cc6_8 n6 n8 7.750000e-18
Cc7_8 n7 n8 1.345500e-16
Cc7_9 n7 n9 7.250000e-18
Cc7_10 n7 n10 1.880000e-18
Cc7_11 n7 n11 0.000000e+00
Cc8_9 n8 n9 1.273200e-16
Cc8_10 n8 n10 2.910000e-18
Cc8_11 n8 n11 0.000000e+00
Cc9_10 n9 n10 1.292200e-16
Cc9_11 n9 n11 1.052000e-17
Cc9_12 n9 n12 0.000000e+00
Cc9_13 n9 n13 0.000000e+00
Cc9_14 n9 n14 0.000000e+00
Cc9_30 n9 n30 0.000000e+00
Cc10_11 n10 n11 1.063300e-16
Cc10_12 n10 n12 1.000000e-18
Cc10_13 n10 n13 0.000000e+00
Cc10_14 n10 n14 0.000000e+00
Cc10_29 n10 n29 0.000000e+00
Cc11_12 n11 n12 1.651300e-16
Cc11_13 n11 n13 0.000000e+00
Cc11_14 n11 n14 0.000000e+00
Cc11_15 n11 n15 0.000000e+00
Cc11_16 n11 n16 0.000000e+00
Cc11_22 n11 n22 0.000000e+00
Cc11_23 n11 n23 0.000000e+00
Cc11_24 n11 n24 0.000000e+00
Cc11_25 n11 n25 0.000000e+00
Cc11_26 n11 n26 4.760000e-18
Cc11_27 n11 n27 4.570000e-18
Cc11_29 n11 n29 1.010000e-18
Cc12_13 n12 n13 1.186200e-16
Cc12_14 n12 n14 7.340000e-18
Cc12_15 n12 n15 0.000000e+00
Cc12_16 n12 n16 0.000000e+00
Cc12_17 n12 n17 0.000000e+00
Cc12_21 n12 n21 0.000000e+00
Cc12_22 n12 n22 0.000000e+00
Cc12_23 n12 n23 0.000000e+00
Cc12_24 n12 n24 0.000000e+00
Cc12_25 n12 n25 0.000000e+00
Cc12_26 n12 n26 1.360000e-18
Cc12_27 n12 n27 6.200000e-18
Cc12_28 n12 n28 0.000000e+00
Cc13_14 n13 n14 1.226800e-16
Cc13_15 n13 n15 1.055000e-17
Cc13_16 n13 n16 4.840000e-18
Cc13_17 n13 n17 0.000000e+00
Cc13_18 n13 n18 0.000000e+00
Cc13_25 n13 n25 0.000000e+00
Cc13_26 n13 n26 1.060000e-18
Cc13_27 n13 n27 0.000000e+00
Cc14_15 n14 n15 1.732300e-16
Cc14_16 n14 n16 1.584000e-17
Cc14_17 n14 n17 0.000000e+00
Cc14_18 n14 n18 0.000000e+00
Cc14_24 n14 n24 0.000000e+00
Cc14_25 n14 n25 1.060000e-18
Cc15_16 n15 n16 8.807000e-17
Cc15_17 n15 n17 1.010000e-18
Cc15_21 n15 n21 0.000000e+00
Cc15_22 n15 n22 0.000000e+00
Cc15_23 n15 n23 0.000000e+00
Cc15_24 n15 n24 1.590000e-18
Cc16_17 n16 n17 1.594600e-16
Cc16_18 n16 n18 9.880000e-18
Cc16_19 n16 n19 3.180000e-18
Cc16_20 n16 n20 0.000000e+00
Cc16_21 n16 n21 5.507000e-17
Cc16_22 n16 n22 7.980000e-18
Cc16_23 n16 n23 2.680000e-18
Cc16_24 n16 n24 0.000000e+00
Cc16_25 n16 n25 0.000000e+00
Cc16_26 n16 n26 0.000000e+00
Cc16_27 n16 n27 0.000000e+00
Cc17_18 n17 n18 9.387000e-17
Cc17_19 n17 n19 7.070000e-18
Cc17_20 n17 n20 0.000000e+00
Cc17_21 n17 n21 5.211000e-17
Cc17_22 n17 n22 4.227000e-17
Cc17_23 n17 n23 1.660000e-18
Cc17_24 n17 n24 0.000000e+00
Cc17_25 n17 n25 0.000000e+00
Cc17_26 n17 n26 0.000000e+00
Cc17_27 n17 n27 0.000000e+00
Cc18_19 n18 n19 1.249500e-16
Cc18_20 n18 n20 1.973000e-17
Cc18_21 n18 n21 3.640000e-18
Cc18_22 n18 n22 0.000000e+00
Cc19_20 n19 n20 1.183400e-16
Cc19_21 n19 n21 2.965000e-17
Cc19_22 n19 n22 1.430000e-18
Cc19_23 n19 n23 0.000000e+00
Cc19_24 n19 n24 0.000000e+00
Cc19_25 n19 n25 0.000000e+00
Cc19_27 n19 n27 0.000000e+00
Cc20_21 n20 n21 8.516000e-17
Cc20_22 n20 n22 5.790000e-18
Cc20_23 n20 n23 0.000000e+00
Cc20_24 n20 n24 0.000000e+00
Cc20_25 n20 n25 0.000000e+00
Cc21_22 n21 n22 1.377700e-16
Cc21_23 n21 n23 2.161000e-17
Cc21_24 n21 n24 0.000000e+00
Cc21_25 n21 n25 0.000000e+00
Cc21_26 n21 n26 0.000000e+00
Cc21_27 n21 n27 0.000000e+00
Cc22_23 n22 n23 1.141800e-16
Cc22_24 n22 n24 4.400000e-18
Cc22_25 n22 n25 0.000000e+00
Cc22_26 n22 n26 0.000000e+00
Cc22_27 n22 n27 0.000000e+00
Cc23_24 n23 n24 7.204000e-17
Cc23_25 n23 n25 0.000000e+00
Cc23_26 n23 n26 0.000000e+00
Cc23_27 n23 n27 2.330000e-18
Cc23_28 n23 n28 0.000000e+00
Cc23_29 n23 n29 0.000000e+00
Cc24_25 n24 n25 6.186000e-17
Cc24_27 n24 n27 0.000000e+00
Cc25_26 n25 n26 6.186000e-17
Cc25_27 n25 n27 3.140000e-18
Cc26_27 n26 n27 8.965000e-17
Cc26_28 n26 n28 0.000000e+00
Cc27_28 n27 n28 6.566000e-17
Cc27_29 n27 n29 0.000000e+00
Cc27_30 n27 n30 0.000000e+00
Cc28_29 n28 n29 5.448000e-17
Cc29_30 n29 n30 5.967000e-17
Cout out 0 7.500000e-15
.save v(out)
.tran 1p 40n
.control
run
meas tran tp TRIG v(out) VAL=0.9 RISE=5 TARG v(out) VAL=0.9 RISE=15
let f = 10 / tp
print f
.endc
.end
