* C12 coupled: lumped loads from a magic extraction
.lib "LIB" tt
.include "CELLS"
.param SUPPLY=1.8
Vdd VPWR 0 {SUPPLY}
Ven EN 0 PULSE(0 1.8 2n 50p 50p 1 2)
Xnand EN n30 0 0 VPWR VPWR n0 sky130_fd_sc_hd__nand2_1
Xi1 n0 0 0 VPWR VPWR n1 sky130_fd_sc_hd__inv_1
Xi2 n1 0 0 VPWR VPWR n2 sky130_fd_sc_hd__inv_1
Xi3 n2 0 0 VPWR VPWR n3 sky130_fd_sc_hd__inv_1
Xi4 n3 0 0 VPWR VPWR n4 sky130_fd_sc_hd__inv_1
Xi5 n4 0 0 VPWR VPWR n5 sky130_fd_sc_hd__inv_1
Xi6 n5 0 0 VPWR VPWR n6 sky130_fd_sc_hd__inv_1
Xi7 n6 0 0 VPWR VPWR n7 sky130_fd_sc_hd__inv_1
Xi8 n7 0 0 VPWR VPWR n8 sky130_fd_sc_hd__inv_1
Xi9 n8 0 0 VPWR VPWR n9 sky130_fd_sc_hd__inv_1
Xi10 n9 0 0 VPWR VPWR n10 sky130_fd_sc_hd__inv_1
Xi11 n10 0 0 VPWR VPWR n11 sky130_fd_sc_hd__inv_1
Xi12 n11 0 0 VPWR VPWR n12 sky130_fd_sc_hd__inv_1
Xi13 n12 0 0 VPWR VPWR n13 sky130_fd_sc_hd__inv_1
Xi14 n13 0 0 VPWR VPWR n14 sky130_fd_sc_hd__inv_1
Xi15 n14 0 0 VPWR VPWR n15 sky130_fd_sc_hd__inv_1
Xi16 n15 0 0 VPWR VPWR n16 sky130_fd_sc_hd__inv_1
Xi17 n16 0 0 VPWR VPWR n17 sky130_fd_sc_hd__inv_1
Xi18 n17 0 0 VPWR VPWR n18 sky130_fd_sc_hd__inv_1
Xi19 n18 0 0 VPWR VPWR n19 sky130_fd_sc_hd__inv_1
Xi20 n19 0 0 VPWR VPWR n20 sky130_fd_sc_hd__inv_1
Xi21 n20 0 0 VPWR VPWR n21 sky130_fd_sc_hd__inv_1
Xi22 n21 0 0 VPWR VPWR n22 sky130_fd_sc_hd__inv_1
Xi23 n22 0 0 VPWR VPWR n23 sky130_fd_sc_hd__inv_1
Xi24 n23 0 0 VPWR VPWR n24 sky130_fd_sc_hd__inv_1
Xi25 n24 0 0 VPWR VPWR n25 sky130_fd_sc_hd__inv_1
Xi26 n25 0 0 VPWR VPWR n26 sky130_fd_sc_hd__inv_1
Xi27 n26 0 0 VPWR VPWR n27 sky130_fd_sc_hd__inv_1
Xi28 n27 0 0 VPWR VPWR n28 sky130_fd_sc_hd__inv_1
Xi29 n28 0 0 VPWR VPWR n29 sky130_fd_sc_hd__inv_1
Xi30 n29 0 0 VPWR VPWR n30 sky130_fd_sc_hd__inv_1
Xbuf n15 0 0 VPWR VPWR out sky130_fd_sc_hd__buf_1
Cn0 n0 0 9.145672e-16
Cn1 n1 0 6.733876e-16
Cn2 n2 0 6.618770e-16
Cn3 n3 0 7.003659e-16
Cn4 n4 0 6.693479e-16
Cn5 n5 0 6.852598e-16
Cn6 n6 0 6.715881e-16
Cn7 n7 0 1.042700e-15
Cn8 n8 0 7.007752e-16
Cn9 n9 0 7.975722e-16
Cn10 n10 0 7.085658e-16
Cn11 n11 0 7.790771e-16
Cn12 n12 0 7.840940e-16
Cn13 n13 0 7.895369e-16
Cn14 n14 0 8.034431e-16
Cn15 n15 0 1.485037e-15
Cn16 n16 0 6.838841e-16
Cn17 n17 0 6.645848e-16
Cn18 n18 0 7.006795e-16
Cn19 n19 0 6.734049e-16
Cn20 n20 0 6.768494e-16
Cn21 n21 0 6.585545e-16
Cn22 n22 0 9.879504e-16
Cn23 n23 0 7.145151e-16
Cn24 n24 0 8.195397e-16
Cn25 n25 0 7.064324e-16
Cn26 n26 0 7.735756e-16
Cn27 n27 0 7.865018e-16
Cn28 n28 0 7.910125e-16
Cn29 n29 0 7.867534e-16
Cn30 n30 0 1.739579e-15
Cc0_1 n0 n1 6.468000e-17
Cc0_2 n0 n2 0.000000e+00
Cc0_3 n0 n3 0.000000e+00
Cc0_4 n0 n4 0.000000e+00
Cc0_5 n0 n5 0.000000e+00
Cc0_6 n0 n6 0.000000e+00
Cc0_7 n0 n7 0.000000e+00
Cc0_13 n0 n13 7.130000e-18
Cc0_14 n0 n14 1.950000e-18
Cc0_15 n0 n15 0.000000e+00
Cc0_30 n0 n30 4.670000e-17
Cc1_2 n1 n2 6.186000e-17
Cc1_7 n1 n7 0.000000e+00
Cc1_12 n1 n12 7.130000e-18
Cc1_16 n1 n16 0.000000e+00
Cc1_30 n1 n30 0.000000e+00
Cc2_3 n2 n3 6.186000e-17
Cc2_7 n2 n7 0.000000e+00
Cc2_11 n2 n11 7.130000e-18
Cc2_12 n2 n12 0.000000e+00
Cc2_17 n2 n17 0.000000e+00
Cc2_30 n2 n30 0.000000e+00
Cc3_4 n3 n4 6.186000e-17
Cc3_7 n3 n7 0.000000e+00
Cc3_10 n3 n10 7.130000e-18
Cc3_18 n3 n18 0.000000e+00
Cc4_5 n4 n5 6.186000e-17
Cc4_7 n4 n7 0.000000e+00
Cc4_9 n4 n9 7.130000e-18
Cc4_10 n4 n10 0.000000e+00
Cc4_19 n4 n19 0.000000e+00
Cc5_6 n5 n6 6.186000e-17
Cc5_7 n5 n7 0.000000e+00
Cc5_8 n5 n8 7.130000e-18
Cc5_20 n5 n20 0.000000e+00
Cc6_7 n6 n7 6.273000e-17
Cc6_8 n6 n8 0.000000e+00
Cc7_8 n7 n8 1.301300e-16
Cc7_9 n7 n9 1.528000e-17
Cc7_10 n7 n10 0.000000e+00
Cc7_11 n7 n11 0.000000e+00
Cc7_12 n7 n12 0.000000e+00
Cc7_13 n7 n13 0.000000e+00
Cc7_14 n7 n14 0.000000e+00
Cc7_21 n7 n21 6.260000e-18
Cc8_9 n8 n9 1.174800e-16
Cc8_10 n8 n10 1.221000e-17
Cc8_11 n8 n11 0.000000e+00
Cc8_12 n8 n12 0.000000e+00
Cc8_15 n8 n15 0.000000e+00
Cc8_20 n8 n20 6.250000e-18
Cc8_22 n8 n22 0.000000e+00
Cc8_23 n8 n23 0.000000e+00
Cc9_10 n9 n10 1.348800e-16
Cc9_11 n9 n11 1.847000e-17
Cc9_12 n9 n12 0.000000e+00
Cc9_15 n9 n15 0.000000e+00
Cc9_19 n9 n19 6.300000e-18
Cc9_20 n9 n20 0.000000e+00
Cc9_24 n9 n24 0.000000e+00
Cc10_11 n10 n11 1.195300e-16
Cc10_12 n10 n12 1.070000e-17
Cc10_15 n10 n15 0.000000e+00
Cc10_18 n10 n18 6.250000e-18
Cc10_25 n10 n25 0.000000e+00
Cc11_12 n11 n12 1.345900e-16
Cc11_13 n11 n13 1.268000e-17
Cc11_14 n11 n14 0.000000e+00
Cc11_15 n11 n15 0.000000e+00
Cc11_17 n11 n17 6.250000e-18
Cc11_18 n11 n18 0.000000e+00
Cc11_26 n11 n26 0.000000e+00
Cc11_30 n11 n30 0.000000e+00
Cc12_13 n12 n13 1.261000e-16
Cc12_14 n12 n14 1.403000e-17
Cc12_15 n12 n15 0.000000e+00
Cc12_16 n12 n16 6.250000e-18
Cc12_27 n12 n27 0.000000e+00
Cc12_30 n12 n30 0.000000e+00
Cc13_14 n13 n14 1.339200e-16
Cc13_15 n13 n15 1.450000e-17
Cc13_16 n13 n16 0.000000e+00
Cc13_28 n13 n28 0.000000e+00
Cc13_30 n13 n30 0.000000e+00
Cc14_15 n14 n15 1.096700e-16
Cc14_29 n14 n29 0.000000e+00
Cc14_30 n14 n30 1.473000e-17
Cc15_16 n15 n16 5.889000e-17
Cc15_17 n15 n17 0.000000e+00
Cc15_18 n15 n18 0.000000e+00
Cc15_19 n15 n19 0.000000e+00
Cc15_20 n15 n20 0.000000e+00
Cc15_22 n15 n22 0.000000e+00
Cc15_28 n15 n28 7.130000e-18
Cc15_29 n15 n29 2.990000e-18
Cc15_30 n15 n30 1.310500e-16
Cc16_17 n16 n17 6.186000e-17
Cc16_22 n16 n22 0.000000e+00
Cc16_27 n16 n27 7.130000e-18
Cc17_18 n17 n18 6.186000e-17
Cc17_22 n17 n22 0.000000e+00
Cc17_26 n17 n26 7.130000e-18
Cc17_27 n17 n27 0.000000e+00
Cc18_19 n18 n19 6.186000e-17
Cc18_22 n18 n22 0.000000e+00
Cc18_25 n18 n25 7.130000e-18
Cc19_20 n19 n20 6.186000e-17
Cc19_22 n19 n22 0.000000e+00
Cc19_24 n19 n24 7.130000e-18
Cc19_25 n19 n25 0.000000e+00
Cc20_21 n20 n21 6.186000e-17
Cc20_22 n20 n22 1.140000e-18
Cc20_23 n20 n23 7.130000e-18
Cc21_22 n21 n22 7.993000e-17
Cc22_23 n22 n23 1.087700e-16
Cc22_24 n22 n24 1.412000e-17
Cc22_25 n22 n25 0.000000e+00
Cc22_26 n22 n26 0.000000e+00
Cc22_27 n22 n27 0.000000e+00
Cc22_28 n22 n28 0.000000e+00
Cc22_29 n22 n29 0.000000e+00
Cc23_24 n23 n24 1.202900e-16
Cc23_25 n23 n25 9.080000e-18
Cc23_26 n23 n26 0.000000e+00
Cc23_27 n23 n27 0.000000e+00
Cc24_25 n24 n25 1.292600e-16
Cc24_26 n24 n26 1.847000e-17
Cc24_27 n24 n27 0.000000e+00
Cc24_30 n24 n30 0.000000e+00
Cc25_26 n25 n26 1.185400e-16
Cc25_27 n25 n27 1.070000e-17
Cc25_28 n25 n28 0.000000e+00
Cc25_30 n25 n30 0.000000e+00
Cc26_27 n26 n27 1.331400e-16
Cc26_28 n26 n28 1.429000e-17
Cc26_29 n26 n29 0.000000e+00
Cc26_30 n26 n30 0.000000e+00
Cc27_28 n27 n28 1.255200e-16
Cc27_29 n27 n29 1.403000e-17
Cc27_30 n27 n30 0.000000e+00
Cc28_29 n28 n29 1.333200e-16
Cc28_30 n28 n30 7.740000e-18
Cc29_30 n29 n30 1.155700e-16
Cout out 0 7.500000e-15
.save v(out)
.tran 1p 40n
.control
run
meas tran tp TRIG v(out) VAL=0.9 RISE=5 TARG v(out) VAL=0.9 RISE=15
let f = 10 / tp
print f
.endc
.end
