* A00: lumped loads from a magic extraction
.lib "LIB" tt
.include "CELLS"
.param SUPPLY=1.8
Vdd VPWR 0 {SUPPLY}
Ven EN 0 PULSE(0 1.8 2n 50p 50p 1 2)
Xnand EN n30 0 0 VPWR VPWR n0 sky130_fd_sc_hd__nand2_1
Xi1 n0 0 0 VPWR VPWR n1 sky130_fd_sc_hd__inv_1
Xi2 n1 0 0 VPWR VPWR n2 sky130_fd_sc_hd__inv_1
Xi3 n2 0 0 VPWR VPWR n3 sky130_fd_sc_hd__inv_1
Xi4 n3 0 0 VPWR VPWR n4 sky130_fd_sc_hd__inv_1
Xi5 n4 0 0 VPWR VPWR n5 sky130_fd_sc_hd__inv_1
Xi6 n5 0 0 VPWR VPWR n6 sky130_fd_sc_hd__inv_1
Xi7 n6 0 0 VPWR VPWR n7 sky130_fd_sc_hd__inv_1
Xi8 n7 0 0 VPWR VPWR n8 sky130_fd_sc_hd__inv_1
Xi9 n8 0 0 VPWR VPWR n9 sky130_fd_sc_hd__inv_1
Xi10 n9 0 0 VPWR VPWR n10 sky130_fd_sc_hd__inv_1
Xi11 n10 0 0 VPWR VPWR n11 sky130_fd_sc_hd__inv_1
Xi12 n11 0 0 VPWR VPWR n12 sky130_fd_sc_hd__inv_1
Xi13 n12 0 0 VPWR VPWR n13 sky130_fd_sc_hd__inv_1
Xi14 n13 0 0 VPWR VPWR n14 sky130_fd_sc_hd__inv_1
Xi15 n14 0 0 VPWR VPWR n15 sky130_fd_sc_hd__inv_1
Xi16 n15 0 0 VPWR VPWR n16 sky130_fd_sc_hd__inv_1
Xi17 n16 0 0 VPWR VPWR n17 sky130_fd_sc_hd__inv_1
Xi18 n17 0 0 VPWR VPWR n18 sky130_fd_sc_hd__inv_1
Xi19 n18 0 0 VPWR VPWR n19 sky130_fd_sc_hd__inv_1
Xi20 n19 0 0 VPWR VPWR n20 sky130_fd_sc_hd__inv_1
Xi21 n20 0 0 VPWR VPWR n21 sky130_fd_sc_hd__inv_1
Xi22 n21 0 0 VPWR VPWR n22 sky130_fd_sc_hd__inv_1
Xi23 n22 0 0 VPWR VPWR n23 sky130_fd_sc_hd__inv_1
Xi24 n23 0 0 VPWR VPWR n24 sky130_fd_sc_hd__inv_1
Xi25 n24 0 0 VPWR VPWR n25 sky130_fd_sc_hd__inv_1
Xi26 n25 0 0 VPWR VPWR n26 sky130_fd_sc_hd__inv_1
Xi27 n26 0 0 VPWR VPWR n27 sky130_fd_sc_hd__inv_1
Xi28 n27 0 0 VPWR VPWR n28 sky130_fd_sc_hd__inv_1
Xi29 n28 0 0 VPWR VPWR n29 sky130_fd_sc_hd__inv_1
Xi30 n29 0 0 VPWR VPWR n30 sky130_fd_sc_hd__inv_1
Xbuf n15 0 0 VPWR VPWR out sky130_fd_sc_hd__buf_1
Cn0 n0 0 1.100250e-15
Cn1 n1 0 6.905000e-16
Cn2 n2 0 9.012000e-16
Cn3 n3 0 1.528640e-15
Cn4 n4 0 1.322720e-15
Cn5 n5 0 1.070260e-15
Cn6 n6 0 8.815200e-16
Cn7 n7 0 8.758800e-16
Cn8 n8 0 8.899900e-16
Cn9 n9 0 1.024810e-15
Cn10 n10 0 8.978000e-16
Cn11 n11 0 1.369200e-15
Cn12 n12 0 1.306330e-15
Cn13 n13 0 8.789300e-16
Cn14 n14 0 1.309430e-15
Cn15 n15 0 1.867580e-15
Cn16 n16 0 1.493510e-15
Cn17 n17 0 1.351630e-15
Cn18 n18 0 1.014270e-15
Cn19 n19 0 9.633400e-16
Cn20 n20 0 1.052470e-15
Cn21 n21 0 1.299170e-15
Cn22 n22 0 1.297800e-15
Cn23 n23 0 1.546960e-15
Cn24 n24 0 6.765600e-16
Cn25 n25 0 6.929800e-16
Cn26 n26 0 6.638700e-16
Cn27 n27 0 1.102980e-15
Cn28 n28 0 6.845400e-16
Cn29 n29 0 1.050680e-15
Cn30 n30 0 7.043400e-16
Cout out 0 7.500000e-15
.save v(out)
.tran 1p 140n
.control
run
meas tran tp TRIG v(out) VAL=0.9 RISE=5 TARG v(out) VAL=0.9 RISE=25
let f = 20 / tp
print f
.endc
.end
