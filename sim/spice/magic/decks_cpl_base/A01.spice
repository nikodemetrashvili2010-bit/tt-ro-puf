* A01 coupled: lumped loads from a magic extraction
.lib "LIB" tt
.include "CELLS"
.param SUPPLY=1.8
Vdd VPWR 0 {SUPPLY}
Ven EN 0 PULSE(0 1.8 2n 50p 50p 1 2)
Xnand EN n30 0 0 VPWR VPWR n0 sky130_fd_sc_hd__nand2_1
Xi1 n0 0 0 VPWR VPWR n1 sky130_fd_sc_hd__inv_1
Xi2 n1 0 0 VPWR VPWR n2 sky130_fd_sc_hd__inv_1
Xi3 n2 0 0 VPWR VPWR n3 sky130_fd_sc_hd__inv_1
Xi4 n3 0 0 VPWR VPWR n4 sky130_fd_sc_hd__inv_1
Xi5 n4 0 0 VPWR VPWR n5 sky130_fd_sc_hd__inv_1
Xi6 n5 0 0 VPWR VPWR n6 sky130_fd_sc_hd__inv_1
Xi7 n6 0 0 VPWR VPWR n7 sky130_fd_sc_hd__inv_1
Xi8 n7 0 0 VPWR VPWR n8 sky130_fd_sc_hd__inv_1
Xi9 n8 0 0 VPWR VPWR n9 sky130_fd_sc_hd__inv_1
Xi10 n9 0 0 VPWR VPWR n10 sky130_fd_sc_hd__inv_1
Xi11 n10 0 0 VPWR VPWR n11 sky130_fd_sc_hd__inv_1
Xi12 n11 0 0 VPWR VPWR n12 sky130_fd_sc_hd__inv_1
Xi13 n12 0 0 VPWR VPWR n13 sky130_fd_sc_hd__inv_1
Xi14 n13 0 0 VPWR VPWR n14 sky130_fd_sc_hd__inv_1
Xi15 n14 0 0 VPWR VPWR n15 sky130_fd_sc_hd__inv_1
Xi16 n15 0 0 VPWR VPWR n16 sky130_fd_sc_hd__inv_1
Xi17 n16 0 0 VPWR VPWR n17 sky130_fd_sc_hd__inv_1
Xi18 n17 0 0 VPWR VPWR n18 sky130_fd_sc_hd__inv_1
Xi19 n18 0 0 VPWR VPWR n19 sky130_fd_sc_hd__inv_1
Xi20 n19 0 0 VPWR VPWR n20 sky130_fd_sc_hd__inv_1
Xi21 n20 0 0 VPWR VPWR n21 sky130_fd_sc_hd__inv_1
Xi22 n21 0 0 VPWR VPWR n22 sky130_fd_sc_hd__inv_1
Xi23 n22 0 0 VPWR VPWR n23 sky130_fd_sc_hd__inv_1
Xi24 n23 0 0 VPWR VPWR n24 sky130_fd_sc_hd__inv_1
Xi25 n24 0 0 VPWR VPWR n25 sky130_fd_sc_hd__inv_1
Xi26 n25 0 0 VPWR VPWR n26 sky130_fd_sc_hd__inv_1
Xi27 n26 0 0 VPWR VPWR n27 sky130_fd_sc_hd__inv_1
Xi28 n27 0 0 VPWR VPWR n28 sky130_fd_sc_hd__inv_1
Xi29 n28 0 0 VPWR VPWR n29 sky130_fd_sc_hd__inv_1
Xi30 n29 0 0 VPWR VPWR n30 sky130_fd_sc_hd__inv_1
Xbuf n15 0 0 VPWR VPWR out sky130_fd_sc_hd__buf_1
Cn0 n0 0 7.628700e-16
Cn1 n1 0 5.392800e-16
Cn2 n2 0 9.678100e-16
Cn3 n3 0 8.536200e-16
Cn4 n4 0 5.644700e-16
Cn5 n5 0 8.296700e-16
Cn6 n6 0 5.982100e-16
Cn7 n7 0 6.177200e-16
Cn8 n8 0 6.428400e-16
Cn9 n9 0 7.558100e-16
Cn10 n10 0 5.931500e-16
Cn11 n11 0 8.763800e-16
Cn12 n12 0 6.573900e-16
Cn13 n13 0 5.872000e-16
Cn14 n14 0 5.585300e-16
Cn15 n15 0 1.969550e-15
Cn16 n16 0 6.918700e-16
Cn17 n17 0 1.095420e-15
Cn18 n18 0 5.814000e-16
Cn19 n19 0 5.377700e-16
Cn20 n20 0 4.982800e-16
Cn21 n21 0 5.066200e-16
Cn22 n22 0 7.874100e-16
Cn23 n23 0 5.681400e-16
Cn24 n24 0 8.219100e-16
Cn25 n25 0 9.310100e-16
Cn26 n26 0 4.961000e-16
Cn27 n27 0 8.865600e-16
Cn28 n28 0 7.386200e-16
Cn29 n29 0 1.022100e-15
Cn30 n30 0 1.749160e-15
Cc0_1 n0 n1 6.475000e-17
Cc0_2 n0 n2 1.040000e-18
Cc0_8 n0 n8 0.000000e+00
Cc0_9 n0 n9 0.000000e+00
Cc0_10 n0 n10 0.000000e+00
Cc0_17 n0 n17 0.000000e+00
Cc0_30 n0 n30 1.102200e-16
Cc1_2 n1 n2 4.684000e-17
Cc1_3 n1 n3 0.000000e+00
Cc1_4 n1 n4 1.160000e-18
Cc1_7 n1 n7 0.000000e+00
Cc1_17 n1 n17 0.000000e+00
Cc1_30 n1 n30 8.818000e-17
Cc2_3 n2 n3 1.051000e-16
Cc2_4 n2 n4 2.666000e-17
Cc2_5 n2 n5 3.149000e-17
Cc2_6 n2 n6 0.000000e+00
Cc2_18 n2 n18 0.000000e+00
Cc2_25 n2 n25 0.000000e+00
Cc2_27 n2 n27 0.000000e+00
Cc2_29 n2 n29 1.410000e-17
Cc2_30 n2 n30 6.824000e-17
Cc3_4 n3 n4 1.465900e-16
Cc3_5 n3 n5 3.091000e-17
Cc3_6 n3 n6 0.000000e+00
Cc3_7 n3 n7 0.000000e+00
Cc3_8 n3 n8 0.000000e+00
Cc3_10 n3 n10 0.000000e+00
Cc3_17 n3 n17 0.000000e+00
Cc3_18 n3 n18 0.000000e+00
Cc3_25 n3 n25 0.000000e+00
Cc3_27 n3 n27 0.000000e+00
Cc3_28 n3 n28 0.000000e+00
Cc3_29 n3 n29 1.223000e-17
Cc3_30 n3 n30 7.260000e-18
Cc4_5 n4 n5 4.743000e-17
Cc4_6 n4 n6 0.000000e+00
Cc4_7 n4 n7 0.000000e+00
Cc4_18 n4 n18 0.000000e+00
Cc4_25 n4 n25 0.000000e+00
Cc4_27 n4 n27 0.000000e+00
Cc4_29 n4 n29 0.000000e+00
Cc4_30 n4 n30 0.000000e+00
Cc5_6 n5 n6 1.224700e-16
Cc5_7 n5 n7 2.214000e-17
Cc5_8 n5 n8 3.180000e-18
Cc5_9 n5 n9 0.000000e+00
Cc5_18 n5 n18 0.000000e+00
Cc5_22 n5 n22 0.000000e+00
Cc5_24 n5 n24 1.120000e-18
Cc5_25 n5 n25 0.000000e+00
Cc5_27 n5 n27 0.000000e+00
Cc5_29 n5 n29 4.510000e-18
Cc5_30 n5 n30 0.000000e+00
Cc6_7 n6 n7 1.314500e-16
Cc6_8 n6 n8 8.310000e-18
Cc6_9 n6 n9 0.000000e+00
Cc6_17 n6 n17 7.130000e-18
Cc6_22 n6 n22 0.000000e+00
Cc6_23 n6 n23 0.000000e+00
Cc6_24 n6 n24 1.390000e-18
Cc6_25 n6 n25 0.000000e+00
Cc6_30 n6 n30 0.000000e+00
Cc7_8 n7 n8 1.438000e-16
Cc7_9 n7 n9 1.540000e-17
Cc7_10 n7 n10 0.000000e+00
Cc7_11 n7 n11 0.000000e+00
Cc7_12 n7 n12 0.000000e+00
Cc7_16 n7 n16 0.000000e+00
Cc7_17 n7 n17 0.000000e+00
Cc7_22 n7 n22 0.000000e+00
Cc7_23 n7 n23 0.000000e+00
Cc7_24 n7 n24 0.000000e+00
Cc7_25 n7 n25 0.000000e+00
Cc7_30 n7 n30 0.000000e+00
Cc8_9 n8 n9 1.171900e-16
Cc8_10 n8 n10 0.000000e+00
Cc8_11 n8 n11 4.080000e-18
Cc8_12 n8 n12 0.000000e+00
Cc8_16 n8 n16 6.150000e-18
Cc8_17 n8 n17 8.970000e-18
Cc8_24 n8 n24 0.000000e+00
Cc8_25 n8 n25 0.000000e+00
Cc9_10 n9 n10 1.393400e-16
Cc9_11 n9 n11 6.890000e-18
Cc9_12 n9 n12 0.000000e+00
Cc9_13 n9 n13 0.000000e+00
Cc9_15 n9 n15 0.000000e+00
Cc9_16 n9 n16 0.000000e+00
Cc9_17 n9 n17 9.094000e-17
Cc9_18 n9 n18 0.000000e+00
Cc9_19 n9 n19 0.000000e+00
Cc9_20 n9 n20 0.000000e+00
Cc9_21 n9 n21 0.000000e+00
Cc9_30 n9 n30 0.000000e+00
Cc10_11 n10 n11 1.016500e-16
Cc10_12 n10 n12 1.090000e-17
Cc10_13 n10 n13 8.080000e-18
Cc10_14 n10 n14 0.000000e+00
Cc10_15 n10 n15 2.160000e-18
Cc10_16 n10 n16 1.430000e-18
Cc10_17 n10 n17 1.424500e-16
Cc10_18 n10 n18 3.470000e-18
Cc10_30 n10 n30 0.000000e+00
Cc11_12 n11 n12 1.095700e-16
Cc11_13 n11 n13 1.189000e-17
Cc11_14 n11 n14 0.000000e+00
Cc11_15 n11 n15 1.046000e-17
Cc11_16 n11 n16 1.184300e-16
Cc11_17 n11 n17 1.264900e-16
Cc11_30 n11 n30 0.000000e+00
Cc12_13 n12 n13 1.076000e-16
Cc12_14 n12 n14 2.670000e-18
Cc12_15 n12 n15 3.861000e-17
Cc12_16 n12 n16 1.636300e-16
Cc12_17 n12 n17 8.750000e-18
Cc13_14 n13 n14 1.314300e-16
Cc13_15 n13 n15 6.645000e-17
Cc13_16 n13 n16 1.203100e-16
Cc13_17 n13 n17 0.000000e+00
Cc13_18 n13 n18 0.000000e+00
Cc13_19 n13 n19 0.000000e+00
Cc14_15 n14 n15 2.080300e-16
Cc14_16 n14 n16 6.190000e-18
Cc15_16 n15 n16 6.553000e-17
Cc15_17 n15 n17 0.000000e+00
Cc16_17 n16 n17 4.965000e-17
Cc16_18 n16 n18 0.000000e+00
Cc16_19 n16 n19 0.000000e+00
Cc17_18 n17 n18 6.279000e-17
Cc17_19 n17 n19 0.000000e+00
Cc17_20 n17 n20 0.000000e+00
Cc17_21 n17 n21 0.000000e+00
Cc17_22 n17 n22 0.000000e+00
Cc17_30 n17 n30 0.000000e+00
Cc18_19 n18 n19 5.885000e-17
Cc18_22 n18 n22 0.000000e+00
Cc19_20 n19 n20 6.095000e-17
Cc19_22 n19 n22 0.000000e+00
Cc19_29 n19 n29 0.000000e+00
Cc20_21 n20 n21 6.186000e-17
Cc20_22 n20 n22 1.760000e-18
Cc20_28 n20 n28 0.000000e+00
Cc20_29 n20 n29 0.000000e+00
Cc21_22 n21 n22 4.800000e-17
Cc21_24 n21 n24 0.000000e+00
Cc21_25 n21 n25 1.090000e-18
Cc21_27 n21 n27 0.000000e+00
Cc21_28 n21 n28 0.000000e+00
Cc22_23 n22 n23 6.993000e-17
Cc22_24 n22 n24 5.587000e-17
Cc22_25 n22 n25 2.145000e-17
Cc22_27 n22 n27 0.000000e+00
Cc22_28 n22 n28 3.830000e-18
Cc23_24 n23 n24 1.292900e-16
Cc23_25 n23 n25 2.339000e-17
Cc23_26 n23 n26 0.000000e+00
Cc23_27 n23 n27 1.610000e-18
Cc24_25 n24 n25 7.304000e-17
Cc24_26 n24 n26 0.000000e+00
Cc24_27 n24 n27 0.000000e+00
Cc24_28 n24 n28 2.650000e-18
Cc25_26 n25 n26 6.268000e-17
Cc25_27 n25 n27 1.082500e-16
Cc25_28 n25 n28 4.307000e-17
Cc25_29 n25 n29 1.200000e-18
Cc25_30 n25 n30 0.000000e+00
Cc26_27 n26 n27 1.499800e-16
Cc26_28 n26 n28 3.470000e-18
Cc26_29 n26 n29 0.000000e+00
Cc26_30 n26 n30 0.000000e+00
Cc27_28 n27 n28 1.369500e-16
Cc27_29 n27 n29 9.510000e-18
Cc27_30 n27 n30 2.110000e-18
Cc28_29 n28 n29 1.116600e-16
Cc28_30 n28 n30 3.630000e-18
Cc29_30 n29 n30 9.888000e-17
Cout out 0 7.500000e-15
.save v(out)
.tran 1p 40n
.control
run
meas tran tp TRIG v(out) VAL=0.9 RISE=5 TARG v(out) VAL=0.9 RISE=15
let f = 10 / tp
print f
.endc
.end
