* SILICON go/no-go : CONTROL (no parasitics)
* auto-generated by gen_decks.py -- 32 ring oscillators, enable-started
.lib /home/pc/pdks/sky130A/libs.tech/ngspice/sky130.lib.spice tt
.include /home/pc/pdks/sky130A/libs.ref/sky130_fd_sc_hd/spice/sky130_fd_sc_hd.spice
.param SUPPLY=1.8
Vdd VPWR 0 {SUPPLY}
Ven EN 0 PULSE(0 1.8 2n 50p 50p 1 2)

* --- RO 0 ---
X0_nand EN x0_n30 0 0 VPWR VPWR x0_n0 sky130_fd_sc_hd__nand2_1
X0_inv1 x0_n0 0 0 VPWR VPWR x0_n1 sky130_fd_sc_hd__inv_1
X0_inv2 x0_n1 0 0 VPWR VPWR x0_n2 sky130_fd_sc_hd__inv_1
X0_inv3 x0_n2 0 0 VPWR VPWR x0_n3 sky130_fd_sc_hd__inv_1
X0_inv4 x0_n3 0 0 VPWR VPWR x0_n4 sky130_fd_sc_hd__inv_1
X0_inv5 x0_n4 0 0 VPWR VPWR x0_n5 sky130_fd_sc_hd__inv_1
X0_inv6 x0_n5 0 0 VPWR VPWR x0_n6 sky130_fd_sc_hd__inv_1
X0_inv7 x0_n6 0 0 VPWR VPWR x0_n7 sky130_fd_sc_hd__inv_1
X0_inv8 x0_n7 0 0 VPWR VPWR x0_n8 sky130_fd_sc_hd__inv_1
X0_inv9 x0_n8 0 0 VPWR VPWR x0_n9 sky130_fd_sc_hd__inv_1
X0_inv10 x0_n9 0 0 VPWR VPWR x0_n10 sky130_fd_sc_hd__inv_1
X0_inv11 x0_n10 0 0 VPWR VPWR x0_n11 sky130_fd_sc_hd__inv_1
X0_inv12 x0_n11 0 0 VPWR VPWR x0_n12 sky130_fd_sc_hd__inv_1
X0_inv13 x0_n12 0 0 VPWR VPWR x0_n13 sky130_fd_sc_hd__inv_1
X0_inv14 x0_n13 0 0 VPWR VPWR x0_n14 sky130_fd_sc_hd__inv_1
X0_inv15 x0_n14 0 0 VPWR VPWR x0_n15 sky130_fd_sc_hd__inv_1
X0_inv16 x0_n15 0 0 VPWR VPWR x0_n16 sky130_fd_sc_hd__inv_1
X0_inv17 x0_n16 0 0 VPWR VPWR x0_n17 sky130_fd_sc_hd__inv_1
X0_inv18 x0_n17 0 0 VPWR VPWR x0_n18 sky130_fd_sc_hd__inv_1
X0_inv19 x0_n18 0 0 VPWR VPWR x0_n19 sky130_fd_sc_hd__inv_1
X0_inv20 x0_n19 0 0 VPWR VPWR x0_n20 sky130_fd_sc_hd__inv_1
X0_inv21 x0_n20 0 0 VPWR VPWR x0_n21 sky130_fd_sc_hd__inv_1
X0_inv22 x0_n21 0 0 VPWR VPWR x0_n22 sky130_fd_sc_hd__inv_1
X0_inv23 x0_n22 0 0 VPWR VPWR x0_n23 sky130_fd_sc_hd__inv_1
X0_inv24 x0_n23 0 0 VPWR VPWR x0_n24 sky130_fd_sc_hd__inv_1
X0_inv25 x0_n24 0 0 VPWR VPWR x0_n25 sky130_fd_sc_hd__inv_1
X0_inv26 x0_n25 0 0 VPWR VPWR x0_n26 sky130_fd_sc_hd__inv_1
X0_inv27 x0_n26 0 0 VPWR VPWR x0_n27 sky130_fd_sc_hd__inv_1
X0_inv28 x0_n27 0 0 VPWR VPWR x0_n28 sky130_fd_sc_hd__inv_1
X0_inv29 x0_n28 0 0 VPWR VPWR x0_n29 sky130_fd_sc_hd__inv_1
X0_inv30 x0_n29 0 0 VPWR VPWR x0_n30 sky130_fd_sc_hd__inv_1
X0_buf x0_n15 0 0 VPWR VPWR x0_out sky130_fd_sc_hd__buf_1
* --- RO 1 ---
X1_nand EN x1_n30 0 0 VPWR VPWR x1_n0 sky130_fd_sc_hd__nand2_1
X1_inv1 x1_n0 0 0 VPWR VPWR x1_n1 sky130_fd_sc_hd__inv_1
X1_inv2 x1_n1 0 0 VPWR VPWR x1_n2 sky130_fd_sc_hd__inv_1
X1_inv3 x1_n2 0 0 VPWR VPWR x1_n3 sky130_fd_sc_hd__inv_1
X1_inv4 x1_n3 0 0 VPWR VPWR x1_n4 sky130_fd_sc_hd__inv_1
X1_inv5 x1_n4 0 0 VPWR VPWR x1_n5 sky130_fd_sc_hd__inv_1
X1_inv6 x1_n5 0 0 VPWR VPWR x1_n6 sky130_fd_sc_hd__inv_1
X1_inv7 x1_n6 0 0 VPWR VPWR x1_n7 sky130_fd_sc_hd__inv_1
X1_inv8 x1_n7 0 0 VPWR VPWR x1_n8 sky130_fd_sc_hd__inv_1
X1_inv9 x1_n8 0 0 VPWR VPWR x1_n9 sky130_fd_sc_hd__inv_1
X1_inv10 x1_n9 0 0 VPWR VPWR x1_n10 sky130_fd_sc_hd__inv_1
X1_inv11 x1_n10 0 0 VPWR VPWR x1_n11 sky130_fd_sc_hd__inv_1
X1_inv12 x1_n11 0 0 VPWR VPWR x1_n12 sky130_fd_sc_hd__inv_1
X1_inv13 x1_n12 0 0 VPWR VPWR x1_n13 sky130_fd_sc_hd__inv_1
X1_inv14 x1_n13 0 0 VPWR VPWR x1_n14 sky130_fd_sc_hd__inv_1
X1_inv15 x1_n14 0 0 VPWR VPWR x1_n15 sky130_fd_sc_hd__inv_1
X1_inv16 x1_n15 0 0 VPWR VPWR x1_n16 sky130_fd_sc_hd__inv_1
X1_inv17 x1_n16 0 0 VPWR VPWR x1_n17 sky130_fd_sc_hd__inv_1
X1_inv18 x1_n17 0 0 VPWR VPWR x1_n18 sky130_fd_sc_hd__inv_1
X1_inv19 x1_n18 0 0 VPWR VPWR x1_n19 sky130_fd_sc_hd__inv_1
X1_inv20 x1_n19 0 0 VPWR VPWR x1_n20 sky130_fd_sc_hd__inv_1
X1_inv21 x1_n20 0 0 VPWR VPWR x1_n21 sky130_fd_sc_hd__inv_1
X1_inv22 x1_n21 0 0 VPWR VPWR x1_n22 sky130_fd_sc_hd__inv_1
X1_inv23 x1_n22 0 0 VPWR VPWR x1_n23 sky130_fd_sc_hd__inv_1
X1_inv24 x1_n23 0 0 VPWR VPWR x1_n24 sky130_fd_sc_hd__inv_1
X1_inv25 x1_n24 0 0 VPWR VPWR x1_n25 sky130_fd_sc_hd__inv_1
X1_inv26 x1_n25 0 0 VPWR VPWR x1_n26 sky130_fd_sc_hd__inv_1
X1_inv27 x1_n26 0 0 VPWR VPWR x1_n27 sky130_fd_sc_hd__inv_1
X1_inv28 x1_n27 0 0 VPWR VPWR x1_n28 sky130_fd_sc_hd__inv_1
X1_inv29 x1_n28 0 0 VPWR VPWR x1_n29 sky130_fd_sc_hd__inv_1
X1_inv30 x1_n29 0 0 VPWR VPWR x1_n30 sky130_fd_sc_hd__inv_1
X1_buf x1_n15 0 0 VPWR VPWR x1_out sky130_fd_sc_hd__buf_1
* --- RO 2 ---
X2_nand EN x2_n30 0 0 VPWR VPWR x2_n0 sky130_fd_sc_hd__nand2_1
X2_inv1 x2_n0 0 0 VPWR VPWR x2_n1 sky130_fd_sc_hd__inv_1
X2_inv2 x2_n1 0 0 VPWR VPWR x2_n2 sky130_fd_sc_hd__inv_1
X2_inv3 x2_n2 0 0 VPWR VPWR x2_n3 sky130_fd_sc_hd__inv_1
X2_inv4 x2_n3 0 0 VPWR VPWR x2_n4 sky130_fd_sc_hd__inv_1
X2_inv5 x2_n4 0 0 VPWR VPWR x2_n5 sky130_fd_sc_hd__inv_1
X2_inv6 x2_n5 0 0 VPWR VPWR x2_n6 sky130_fd_sc_hd__inv_1
X2_inv7 x2_n6 0 0 VPWR VPWR x2_n7 sky130_fd_sc_hd__inv_1
X2_inv8 x2_n7 0 0 VPWR VPWR x2_n8 sky130_fd_sc_hd__inv_1
X2_inv9 x2_n8 0 0 VPWR VPWR x2_n9 sky130_fd_sc_hd__inv_1
X2_inv10 x2_n9 0 0 VPWR VPWR x2_n10 sky130_fd_sc_hd__inv_1
X2_inv11 x2_n10 0 0 VPWR VPWR x2_n11 sky130_fd_sc_hd__inv_1
X2_inv12 x2_n11 0 0 VPWR VPWR x2_n12 sky130_fd_sc_hd__inv_1
X2_inv13 x2_n12 0 0 VPWR VPWR x2_n13 sky130_fd_sc_hd__inv_1
X2_inv14 x2_n13 0 0 VPWR VPWR x2_n14 sky130_fd_sc_hd__inv_1
X2_inv15 x2_n14 0 0 VPWR VPWR x2_n15 sky130_fd_sc_hd__inv_1
X2_inv16 x2_n15 0 0 VPWR VPWR x2_n16 sky130_fd_sc_hd__inv_1
X2_inv17 x2_n16 0 0 VPWR VPWR x2_n17 sky130_fd_sc_hd__inv_1
X2_inv18 x2_n17 0 0 VPWR VPWR x2_n18 sky130_fd_sc_hd__inv_1
X2_inv19 x2_n18 0 0 VPWR VPWR x2_n19 sky130_fd_sc_hd__inv_1
X2_inv20 x2_n19 0 0 VPWR VPWR x2_n20 sky130_fd_sc_hd__inv_1
X2_inv21 x2_n20 0 0 VPWR VPWR x2_n21 sky130_fd_sc_hd__inv_1
X2_inv22 x2_n21 0 0 VPWR VPWR x2_n22 sky130_fd_sc_hd__inv_1
X2_inv23 x2_n22 0 0 VPWR VPWR x2_n23 sky130_fd_sc_hd__inv_1
X2_inv24 x2_n23 0 0 VPWR VPWR x2_n24 sky130_fd_sc_hd__inv_1
X2_inv25 x2_n24 0 0 VPWR VPWR x2_n25 sky130_fd_sc_hd__inv_1
X2_inv26 x2_n25 0 0 VPWR VPWR x2_n26 sky130_fd_sc_hd__inv_1
X2_inv27 x2_n26 0 0 VPWR VPWR x2_n27 sky130_fd_sc_hd__inv_1
X2_inv28 x2_n27 0 0 VPWR VPWR x2_n28 sky130_fd_sc_hd__inv_1
X2_inv29 x2_n28 0 0 VPWR VPWR x2_n29 sky130_fd_sc_hd__inv_1
X2_inv30 x2_n29 0 0 VPWR VPWR x2_n30 sky130_fd_sc_hd__inv_1
X2_buf x2_n15 0 0 VPWR VPWR x2_out sky130_fd_sc_hd__buf_1
* --- RO 3 ---
X3_nand EN x3_n30 0 0 VPWR VPWR x3_n0 sky130_fd_sc_hd__nand2_1
X3_inv1 x3_n0 0 0 VPWR VPWR x3_n1 sky130_fd_sc_hd__inv_1
X3_inv2 x3_n1 0 0 VPWR VPWR x3_n2 sky130_fd_sc_hd__inv_1
X3_inv3 x3_n2 0 0 VPWR VPWR x3_n3 sky130_fd_sc_hd__inv_1
X3_inv4 x3_n3 0 0 VPWR VPWR x3_n4 sky130_fd_sc_hd__inv_1
X3_inv5 x3_n4 0 0 VPWR VPWR x3_n5 sky130_fd_sc_hd__inv_1
X3_inv6 x3_n5 0 0 VPWR VPWR x3_n6 sky130_fd_sc_hd__inv_1
X3_inv7 x3_n6 0 0 VPWR VPWR x3_n7 sky130_fd_sc_hd__inv_1
X3_inv8 x3_n7 0 0 VPWR VPWR x3_n8 sky130_fd_sc_hd__inv_1
X3_inv9 x3_n8 0 0 VPWR VPWR x3_n9 sky130_fd_sc_hd__inv_1
X3_inv10 x3_n9 0 0 VPWR VPWR x3_n10 sky130_fd_sc_hd__inv_1
X3_inv11 x3_n10 0 0 VPWR VPWR x3_n11 sky130_fd_sc_hd__inv_1
X3_inv12 x3_n11 0 0 VPWR VPWR x3_n12 sky130_fd_sc_hd__inv_1
X3_inv13 x3_n12 0 0 VPWR VPWR x3_n13 sky130_fd_sc_hd__inv_1
X3_inv14 x3_n13 0 0 VPWR VPWR x3_n14 sky130_fd_sc_hd__inv_1
X3_inv15 x3_n14 0 0 VPWR VPWR x3_n15 sky130_fd_sc_hd__inv_1
X3_inv16 x3_n15 0 0 VPWR VPWR x3_n16 sky130_fd_sc_hd__inv_1
X3_inv17 x3_n16 0 0 VPWR VPWR x3_n17 sky130_fd_sc_hd__inv_1
X3_inv18 x3_n17 0 0 VPWR VPWR x3_n18 sky130_fd_sc_hd__inv_1
X3_inv19 x3_n18 0 0 VPWR VPWR x3_n19 sky130_fd_sc_hd__inv_1
X3_inv20 x3_n19 0 0 VPWR VPWR x3_n20 sky130_fd_sc_hd__inv_1
X3_inv21 x3_n20 0 0 VPWR VPWR x3_n21 sky130_fd_sc_hd__inv_1
X3_inv22 x3_n21 0 0 VPWR VPWR x3_n22 sky130_fd_sc_hd__inv_1
X3_inv23 x3_n22 0 0 VPWR VPWR x3_n23 sky130_fd_sc_hd__inv_1
X3_inv24 x3_n23 0 0 VPWR VPWR x3_n24 sky130_fd_sc_hd__inv_1
X3_inv25 x3_n24 0 0 VPWR VPWR x3_n25 sky130_fd_sc_hd__inv_1
X3_inv26 x3_n25 0 0 VPWR VPWR x3_n26 sky130_fd_sc_hd__inv_1
X3_inv27 x3_n26 0 0 VPWR VPWR x3_n27 sky130_fd_sc_hd__inv_1
X3_inv28 x3_n27 0 0 VPWR VPWR x3_n28 sky130_fd_sc_hd__inv_1
X3_inv29 x3_n28 0 0 VPWR VPWR x3_n29 sky130_fd_sc_hd__inv_1
X3_inv30 x3_n29 0 0 VPWR VPWR x3_n30 sky130_fd_sc_hd__inv_1
X3_buf x3_n15 0 0 VPWR VPWR x3_out sky130_fd_sc_hd__buf_1
* --- RO 4 ---
X4_nand EN x4_n30 0 0 VPWR VPWR x4_n0 sky130_fd_sc_hd__nand2_1
X4_inv1 x4_n0 0 0 VPWR VPWR x4_n1 sky130_fd_sc_hd__inv_1
X4_inv2 x4_n1 0 0 VPWR VPWR x4_n2 sky130_fd_sc_hd__inv_1
X4_inv3 x4_n2 0 0 VPWR VPWR x4_n3 sky130_fd_sc_hd__inv_1
X4_inv4 x4_n3 0 0 VPWR VPWR x4_n4 sky130_fd_sc_hd__inv_1
X4_inv5 x4_n4 0 0 VPWR VPWR x4_n5 sky130_fd_sc_hd__inv_1
X4_inv6 x4_n5 0 0 VPWR VPWR x4_n6 sky130_fd_sc_hd__inv_1
X4_inv7 x4_n6 0 0 VPWR VPWR x4_n7 sky130_fd_sc_hd__inv_1
X4_inv8 x4_n7 0 0 VPWR VPWR x4_n8 sky130_fd_sc_hd__inv_1
X4_inv9 x4_n8 0 0 VPWR VPWR x4_n9 sky130_fd_sc_hd__inv_1
X4_inv10 x4_n9 0 0 VPWR VPWR x4_n10 sky130_fd_sc_hd__inv_1
X4_inv11 x4_n10 0 0 VPWR VPWR x4_n11 sky130_fd_sc_hd__inv_1
X4_inv12 x4_n11 0 0 VPWR VPWR x4_n12 sky130_fd_sc_hd__inv_1
X4_inv13 x4_n12 0 0 VPWR VPWR x4_n13 sky130_fd_sc_hd__inv_1
X4_inv14 x4_n13 0 0 VPWR VPWR x4_n14 sky130_fd_sc_hd__inv_1
X4_inv15 x4_n14 0 0 VPWR VPWR x4_n15 sky130_fd_sc_hd__inv_1
X4_inv16 x4_n15 0 0 VPWR VPWR x4_n16 sky130_fd_sc_hd__inv_1
X4_inv17 x4_n16 0 0 VPWR VPWR x4_n17 sky130_fd_sc_hd__inv_1
X4_inv18 x4_n17 0 0 VPWR VPWR x4_n18 sky130_fd_sc_hd__inv_1
X4_inv19 x4_n18 0 0 VPWR VPWR x4_n19 sky130_fd_sc_hd__inv_1
X4_inv20 x4_n19 0 0 VPWR VPWR x4_n20 sky130_fd_sc_hd__inv_1
X4_inv21 x4_n20 0 0 VPWR VPWR x4_n21 sky130_fd_sc_hd__inv_1
X4_inv22 x4_n21 0 0 VPWR VPWR x4_n22 sky130_fd_sc_hd__inv_1
X4_inv23 x4_n22 0 0 VPWR VPWR x4_n23 sky130_fd_sc_hd__inv_1
X4_inv24 x4_n23 0 0 VPWR VPWR x4_n24 sky130_fd_sc_hd__inv_1
X4_inv25 x4_n24 0 0 VPWR VPWR x4_n25 sky130_fd_sc_hd__inv_1
X4_inv26 x4_n25 0 0 VPWR VPWR x4_n26 sky130_fd_sc_hd__inv_1
X4_inv27 x4_n26 0 0 VPWR VPWR x4_n27 sky130_fd_sc_hd__inv_1
X4_inv28 x4_n27 0 0 VPWR VPWR x4_n28 sky130_fd_sc_hd__inv_1
X4_inv29 x4_n28 0 0 VPWR VPWR x4_n29 sky130_fd_sc_hd__inv_1
X4_inv30 x4_n29 0 0 VPWR VPWR x4_n30 sky130_fd_sc_hd__inv_1
X4_buf x4_n15 0 0 VPWR VPWR x4_out sky130_fd_sc_hd__buf_1
* --- RO 5 ---
X5_nand EN x5_n30 0 0 VPWR VPWR x5_n0 sky130_fd_sc_hd__nand2_1
X5_inv1 x5_n0 0 0 VPWR VPWR x5_n1 sky130_fd_sc_hd__inv_1
X5_inv2 x5_n1 0 0 VPWR VPWR x5_n2 sky130_fd_sc_hd__inv_1
X5_inv3 x5_n2 0 0 VPWR VPWR x5_n3 sky130_fd_sc_hd__inv_1
X5_inv4 x5_n3 0 0 VPWR VPWR x5_n4 sky130_fd_sc_hd__inv_1
X5_inv5 x5_n4 0 0 VPWR VPWR x5_n5 sky130_fd_sc_hd__inv_1
X5_inv6 x5_n5 0 0 VPWR VPWR x5_n6 sky130_fd_sc_hd__inv_1
X5_inv7 x5_n6 0 0 VPWR VPWR x5_n7 sky130_fd_sc_hd__inv_1
X5_inv8 x5_n7 0 0 VPWR VPWR x5_n8 sky130_fd_sc_hd__inv_1
X5_inv9 x5_n8 0 0 VPWR VPWR x5_n9 sky130_fd_sc_hd__inv_1
X5_inv10 x5_n9 0 0 VPWR VPWR x5_n10 sky130_fd_sc_hd__inv_1
X5_inv11 x5_n10 0 0 VPWR VPWR x5_n11 sky130_fd_sc_hd__inv_1
X5_inv12 x5_n11 0 0 VPWR VPWR x5_n12 sky130_fd_sc_hd__inv_1
X5_inv13 x5_n12 0 0 VPWR VPWR x5_n13 sky130_fd_sc_hd__inv_1
X5_inv14 x5_n13 0 0 VPWR VPWR x5_n14 sky130_fd_sc_hd__inv_1
X5_inv15 x5_n14 0 0 VPWR VPWR x5_n15 sky130_fd_sc_hd__inv_1
X5_inv16 x5_n15 0 0 VPWR VPWR x5_n16 sky130_fd_sc_hd__inv_1
X5_inv17 x5_n16 0 0 VPWR VPWR x5_n17 sky130_fd_sc_hd__inv_1
X5_inv18 x5_n17 0 0 VPWR VPWR x5_n18 sky130_fd_sc_hd__inv_1
X5_inv19 x5_n18 0 0 VPWR VPWR x5_n19 sky130_fd_sc_hd__inv_1
X5_inv20 x5_n19 0 0 VPWR VPWR x5_n20 sky130_fd_sc_hd__inv_1
X5_inv21 x5_n20 0 0 VPWR VPWR x5_n21 sky130_fd_sc_hd__inv_1
X5_inv22 x5_n21 0 0 VPWR VPWR x5_n22 sky130_fd_sc_hd__inv_1
X5_inv23 x5_n22 0 0 VPWR VPWR x5_n23 sky130_fd_sc_hd__inv_1
X5_inv24 x5_n23 0 0 VPWR VPWR x5_n24 sky130_fd_sc_hd__inv_1
X5_inv25 x5_n24 0 0 VPWR VPWR x5_n25 sky130_fd_sc_hd__inv_1
X5_inv26 x5_n25 0 0 VPWR VPWR x5_n26 sky130_fd_sc_hd__inv_1
X5_inv27 x5_n26 0 0 VPWR VPWR x5_n27 sky130_fd_sc_hd__inv_1
X5_inv28 x5_n27 0 0 VPWR VPWR x5_n28 sky130_fd_sc_hd__inv_1
X5_inv29 x5_n28 0 0 VPWR VPWR x5_n29 sky130_fd_sc_hd__inv_1
X5_inv30 x5_n29 0 0 VPWR VPWR x5_n30 sky130_fd_sc_hd__inv_1
X5_buf x5_n15 0 0 VPWR VPWR x5_out sky130_fd_sc_hd__buf_1
* --- RO 6 ---
X6_nand EN x6_n30 0 0 VPWR VPWR x6_n0 sky130_fd_sc_hd__nand2_1
X6_inv1 x6_n0 0 0 VPWR VPWR x6_n1 sky130_fd_sc_hd__inv_1
X6_inv2 x6_n1 0 0 VPWR VPWR x6_n2 sky130_fd_sc_hd__inv_1
X6_inv3 x6_n2 0 0 VPWR VPWR x6_n3 sky130_fd_sc_hd__inv_1
X6_inv4 x6_n3 0 0 VPWR VPWR x6_n4 sky130_fd_sc_hd__inv_1
X6_inv5 x6_n4 0 0 VPWR VPWR x6_n5 sky130_fd_sc_hd__inv_1
X6_inv6 x6_n5 0 0 VPWR VPWR x6_n6 sky130_fd_sc_hd__inv_1
X6_inv7 x6_n6 0 0 VPWR VPWR x6_n7 sky130_fd_sc_hd__inv_1
X6_inv8 x6_n7 0 0 VPWR VPWR x6_n8 sky130_fd_sc_hd__inv_1
X6_inv9 x6_n8 0 0 VPWR VPWR x6_n9 sky130_fd_sc_hd__inv_1
X6_inv10 x6_n9 0 0 VPWR VPWR x6_n10 sky130_fd_sc_hd__inv_1
X6_inv11 x6_n10 0 0 VPWR VPWR x6_n11 sky130_fd_sc_hd__inv_1
X6_inv12 x6_n11 0 0 VPWR VPWR x6_n12 sky130_fd_sc_hd__inv_1
X6_inv13 x6_n12 0 0 VPWR VPWR x6_n13 sky130_fd_sc_hd__inv_1
X6_inv14 x6_n13 0 0 VPWR VPWR x6_n14 sky130_fd_sc_hd__inv_1
X6_inv15 x6_n14 0 0 VPWR VPWR x6_n15 sky130_fd_sc_hd__inv_1
X6_inv16 x6_n15 0 0 VPWR VPWR x6_n16 sky130_fd_sc_hd__inv_1
X6_inv17 x6_n16 0 0 VPWR VPWR x6_n17 sky130_fd_sc_hd__inv_1
X6_inv18 x6_n17 0 0 VPWR VPWR x6_n18 sky130_fd_sc_hd__inv_1
X6_inv19 x6_n18 0 0 VPWR VPWR x6_n19 sky130_fd_sc_hd__inv_1
X6_inv20 x6_n19 0 0 VPWR VPWR x6_n20 sky130_fd_sc_hd__inv_1
X6_inv21 x6_n20 0 0 VPWR VPWR x6_n21 sky130_fd_sc_hd__inv_1
X6_inv22 x6_n21 0 0 VPWR VPWR x6_n22 sky130_fd_sc_hd__inv_1
X6_inv23 x6_n22 0 0 VPWR VPWR x6_n23 sky130_fd_sc_hd__inv_1
X6_inv24 x6_n23 0 0 VPWR VPWR x6_n24 sky130_fd_sc_hd__inv_1
X6_inv25 x6_n24 0 0 VPWR VPWR x6_n25 sky130_fd_sc_hd__inv_1
X6_inv26 x6_n25 0 0 VPWR VPWR x6_n26 sky130_fd_sc_hd__inv_1
X6_inv27 x6_n26 0 0 VPWR VPWR x6_n27 sky130_fd_sc_hd__inv_1
X6_inv28 x6_n27 0 0 VPWR VPWR x6_n28 sky130_fd_sc_hd__inv_1
X6_inv29 x6_n28 0 0 VPWR VPWR x6_n29 sky130_fd_sc_hd__inv_1
X6_inv30 x6_n29 0 0 VPWR VPWR x6_n30 sky130_fd_sc_hd__inv_1
X6_buf x6_n15 0 0 VPWR VPWR x6_out sky130_fd_sc_hd__buf_1
* --- RO 7 ---
X7_nand EN x7_n30 0 0 VPWR VPWR x7_n0 sky130_fd_sc_hd__nand2_1
X7_inv1 x7_n0 0 0 VPWR VPWR x7_n1 sky130_fd_sc_hd__inv_1
X7_inv2 x7_n1 0 0 VPWR VPWR x7_n2 sky130_fd_sc_hd__inv_1
X7_inv3 x7_n2 0 0 VPWR VPWR x7_n3 sky130_fd_sc_hd__inv_1
X7_inv4 x7_n3 0 0 VPWR VPWR x7_n4 sky130_fd_sc_hd__inv_1
X7_inv5 x7_n4 0 0 VPWR VPWR x7_n5 sky130_fd_sc_hd__inv_1
X7_inv6 x7_n5 0 0 VPWR VPWR x7_n6 sky130_fd_sc_hd__inv_1
X7_inv7 x7_n6 0 0 VPWR VPWR x7_n7 sky130_fd_sc_hd__inv_1
X7_inv8 x7_n7 0 0 VPWR VPWR x7_n8 sky130_fd_sc_hd__inv_1
X7_inv9 x7_n8 0 0 VPWR VPWR x7_n9 sky130_fd_sc_hd__inv_1
X7_inv10 x7_n9 0 0 VPWR VPWR x7_n10 sky130_fd_sc_hd__inv_1
X7_inv11 x7_n10 0 0 VPWR VPWR x7_n11 sky130_fd_sc_hd__inv_1
X7_inv12 x7_n11 0 0 VPWR VPWR x7_n12 sky130_fd_sc_hd__inv_1
X7_inv13 x7_n12 0 0 VPWR VPWR x7_n13 sky130_fd_sc_hd__inv_1
X7_inv14 x7_n13 0 0 VPWR VPWR x7_n14 sky130_fd_sc_hd__inv_1
X7_inv15 x7_n14 0 0 VPWR VPWR x7_n15 sky130_fd_sc_hd__inv_1
X7_inv16 x7_n15 0 0 VPWR VPWR x7_n16 sky130_fd_sc_hd__inv_1
X7_inv17 x7_n16 0 0 VPWR VPWR x7_n17 sky130_fd_sc_hd__inv_1
X7_inv18 x7_n17 0 0 VPWR VPWR x7_n18 sky130_fd_sc_hd__inv_1
X7_inv19 x7_n18 0 0 VPWR VPWR x7_n19 sky130_fd_sc_hd__inv_1
X7_inv20 x7_n19 0 0 VPWR VPWR x7_n20 sky130_fd_sc_hd__inv_1
X7_inv21 x7_n20 0 0 VPWR VPWR x7_n21 sky130_fd_sc_hd__inv_1
X7_inv22 x7_n21 0 0 VPWR VPWR x7_n22 sky130_fd_sc_hd__inv_1
X7_inv23 x7_n22 0 0 VPWR VPWR x7_n23 sky130_fd_sc_hd__inv_1
X7_inv24 x7_n23 0 0 VPWR VPWR x7_n24 sky130_fd_sc_hd__inv_1
X7_inv25 x7_n24 0 0 VPWR VPWR x7_n25 sky130_fd_sc_hd__inv_1
X7_inv26 x7_n25 0 0 VPWR VPWR x7_n26 sky130_fd_sc_hd__inv_1
X7_inv27 x7_n26 0 0 VPWR VPWR x7_n27 sky130_fd_sc_hd__inv_1
X7_inv28 x7_n27 0 0 VPWR VPWR x7_n28 sky130_fd_sc_hd__inv_1
X7_inv29 x7_n28 0 0 VPWR VPWR x7_n29 sky130_fd_sc_hd__inv_1
X7_inv30 x7_n29 0 0 VPWR VPWR x7_n30 sky130_fd_sc_hd__inv_1
X7_buf x7_n15 0 0 VPWR VPWR x7_out sky130_fd_sc_hd__buf_1
* --- RO 8 ---
X8_nand EN x8_n30 0 0 VPWR VPWR x8_n0 sky130_fd_sc_hd__nand2_1
X8_inv1 x8_n0 0 0 VPWR VPWR x8_n1 sky130_fd_sc_hd__inv_1
X8_inv2 x8_n1 0 0 VPWR VPWR x8_n2 sky130_fd_sc_hd__inv_1
X8_inv3 x8_n2 0 0 VPWR VPWR x8_n3 sky130_fd_sc_hd__inv_1
X8_inv4 x8_n3 0 0 VPWR VPWR x8_n4 sky130_fd_sc_hd__inv_1
X8_inv5 x8_n4 0 0 VPWR VPWR x8_n5 sky130_fd_sc_hd__inv_1
X8_inv6 x8_n5 0 0 VPWR VPWR x8_n6 sky130_fd_sc_hd__inv_1
X8_inv7 x8_n6 0 0 VPWR VPWR x8_n7 sky130_fd_sc_hd__inv_1
X8_inv8 x8_n7 0 0 VPWR VPWR x8_n8 sky130_fd_sc_hd__inv_1
X8_inv9 x8_n8 0 0 VPWR VPWR x8_n9 sky130_fd_sc_hd__inv_1
X8_inv10 x8_n9 0 0 VPWR VPWR x8_n10 sky130_fd_sc_hd__inv_1
X8_inv11 x8_n10 0 0 VPWR VPWR x8_n11 sky130_fd_sc_hd__inv_1
X8_inv12 x8_n11 0 0 VPWR VPWR x8_n12 sky130_fd_sc_hd__inv_1
X8_inv13 x8_n12 0 0 VPWR VPWR x8_n13 sky130_fd_sc_hd__inv_1
X8_inv14 x8_n13 0 0 VPWR VPWR x8_n14 sky130_fd_sc_hd__inv_1
X8_inv15 x8_n14 0 0 VPWR VPWR x8_n15 sky130_fd_sc_hd__inv_1
X8_inv16 x8_n15 0 0 VPWR VPWR x8_n16 sky130_fd_sc_hd__inv_1
X8_inv17 x8_n16 0 0 VPWR VPWR x8_n17 sky130_fd_sc_hd__inv_1
X8_inv18 x8_n17 0 0 VPWR VPWR x8_n18 sky130_fd_sc_hd__inv_1
X8_inv19 x8_n18 0 0 VPWR VPWR x8_n19 sky130_fd_sc_hd__inv_1
X8_inv20 x8_n19 0 0 VPWR VPWR x8_n20 sky130_fd_sc_hd__inv_1
X8_inv21 x8_n20 0 0 VPWR VPWR x8_n21 sky130_fd_sc_hd__inv_1
X8_inv22 x8_n21 0 0 VPWR VPWR x8_n22 sky130_fd_sc_hd__inv_1
X8_inv23 x8_n22 0 0 VPWR VPWR x8_n23 sky130_fd_sc_hd__inv_1
X8_inv24 x8_n23 0 0 VPWR VPWR x8_n24 sky130_fd_sc_hd__inv_1
X8_inv25 x8_n24 0 0 VPWR VPWR x8_n25 sky130_fd_sc_hd__inv_1
X8_inv26 x8_n25 0 0 VPWR VPWR x8_n26 sky130_fd_sc_hd__inv_1
X8_inv27 x8_n26 0 0 VPWR VPWR x8_n27 sky130_fd_sc_hd__inv_1
X8_inv28 x8_n27 0 0 VPWR VPWR x8_n28 sky130_fd_sc_hd__inv_1
X8_inv29 x8_n28 0 0 VPWR VPWR x8_n29 sky130_fd_sc_hd__inv_1
X8_inv30 x8_n29 0 0 VPWR VPWR x8_n30 sky130_fd_sc_hd__inv_1
X8_buf x8_n15 0 0 VPWR VPWR x8_out sky130_fd_sc_hd__buf_1
* --- RO 9 ---
X9_nand EN x9_n30 0 0 VPWR VPWR x9_n0 sky130_fd_sc_hd__nand2_1
X9_inv1 x9_n0 0 0 VPWR VPWR x9_n1 sky130_fd_sc_hd__inv_1
X9_inv2 x9_n1 0 0 VPWR VPWR x9_n2 sky130_fd_sc_hd__inv_1
X9_inv3 x9_n2 0 0 VPWR VPWR x9_n3 sky130_fd_sc_hd__inv_1
X9_inv4 x9_n3 0 0 VPWR VPWR x9_n4 sky130_fd_sc_hd__inv_1
X9_inv5 x9_n4 0 0 VPWR VPWR x9_n5 sky130_fd_sc_hd__inv_1
X9_inv6 x9_n5 0 0 VPWR VPWR x9_n6 sky130_fd_sc_hd__inv_1
X9_inv7 x9_n6 0 0 VPWR VPWR x9_n7 sky130_fd_sc_hd__inv_1
X9_inv8 x9_n7 0 0 VPWR VPWR x9_n8 sky130_fd_sc_hd__inv_1
X9_inv9 x9_n8 0 0 VPWR VPWR x9_n9 sky130_fd_sc_hd__inv_1
X9_inv10 x9_n9 0 0 VPWR VPWR x9_n10 sky130_fd_sc_hd__inv_1
X9_inv11 x9_n10 0 0 VPWR VPWR x9_n11 sky130_fd_sc_hd__inv_1
X9_inv12 x9_n11 0 0 VPWR VPWR x9_n12 sky130_fd_sc_hd__inv_1
X9_inv13 x9_n12 0 0 VPWR VPWR x9_n13 sky130_fd_sc_hd__inv_1
X9_inv14 x9_n13 0 0 VPWR VPWR x9_n14 sky130_fd_sc_hd__inv_1
X9_inv15 x9_n14 0 0 VPWR VPWR x9_n15 sky130_fd_sc_hd__inv_1
X9_inv16 x9_n15 0 0 VPWR VPWR x9_n16 sky130_fd_sc_hd__inv_1
X9_inv17 x9_n16 0 0 VPWR VPWR x9_n17 sky130_fd_sc_hd__inv_1
X9_inv18 x9_n17 0 0 VPWR VPWR x9_n18 sky130_fd_sc_hd__inv_1
X9_inv19 x9_n18 0 0 VPWR VPWR x9_n19 sky130_fd_sc_hd__inv_1
X9_inv20 x9_n19 0 0 VPWR VPWR x9_n20 sky130_fd_sc_hd__inv_1
X9_inv21 x9_n20 0 0 VPWR VPWR x9_n21 sky130_fd_sc_hd__inv_1
X9_inv22 x9_n21 0 0 VPWR VPWR x9_n22 sky130_fd_sc_hd__inv_1
X9_inv23 x9_n22 0 0 VPWR VPWR x9_n23 sky130_fd_sc_hd__inv_1
X9_inv24 x9_n23 0 0 VPWR VPWR x9_n24 sky130_fd_sc_hd__inv_1
X9_inv25 x9_n24 0 0 VPWR VPWR x9_n25 sky130_fd_sc_hd__inv_1
X9_inv26 x9_n25 0 0 VPWR VPWR x9_n26 sky130_fd_sc_hd__inv_1
X9_inv27 x9_n26 0 0 VPWR VPWR x9_n27 sky130_fd_sc_hd__inv_1
X9_inv28 x9_n27 0 0 VPWR VPWR x9_n28 sky130_fd_sc_hd__inv_1
X9_inv29 x9_n28 0 0 VPWR VPWR x9_n29 sky130_fd_sc_hd__inv_1
X9_inv30 x9_n29 0 0 VPWR VPWR x9_n30 sky130_fd_sc_hd__inv_1
X9_buf x9_n15 0 0 VPWR VPWR x9_out sky130_fd_sc_hd__buf_1
* --- RO 10 ---
X10_nand EN x10_n30 0 0 VPWR VPWR x10_n0 sky130_fd_sc_hd__nand2_1
X10_inv1 x10_n0 0 0 VPWR VPWR x10_n1 sky130_fd_sc_hd__inv_1
X10_inv2 x10_n1 0 0 VPWR VPWR x10_n2 sky130_fd_sc_hd__inv_1
X10_inv3 x10_n2 0 0 VPWR VPWR x10_n3 sky130_fd_sc_hd__inv_1
X10_inv4 x10_n3 0 0 VPWR VPWR x10_n4 sky130_fd_sc_hd__inv_1
X10_inv5 x10_n4 0 0 VPWR VPWR x10_n5 sky130_fd_sc_hd__inv_1
X10_inv6 x10_n5 0 0 VPWR VPWR x10_n6 sky130_fd_sc_hd__inv_1
X10_inv7 x10_n6 0 0 VPWR VPWR x10_n7 sky130_fd_sc_hd__inv_1
X10_inv8 x10_n7 0 0 VPWR VPWR x10_n8 sky130_fd_sc_hd__inv_1
X10_inv9 x10_n8 0 0 VPWR VPWR x10_n9 sky130_fd_sc_hd__inv_1
X10_inv10 x10_n9 0 0 VPWR VPWR x10_n10 sky130_fd_sc_hd__inv_1
X10_inv11 x10_n10 0 0 VPWR VPWR x10_n11 sky130_fd_sc_hd__inv_1
X10_inv12 x10_n11 0 0 VPWR VPWR x10_n12 sky130_fd_sc_hd__inv_1
X10_inv13 x10_n12 0 0 VPWR VPWR x10_n13 sky130_fd_sc_hd__inv_1
X10_inv14 x10_n13 0 0 VPWR VPWR x10_n14 sky130_fd_sc_hd__inv_1
X10_inv15 x10_n14 0 0 VPWR VPWR x10_n15 sky130_fd_sc_hd__inv_1
X10_inv16 x10_n15 0 0 VPWR VPWR x10_n16 sky130_fd_sc_hd__inv_1
X10_inv17 x10_n16 0 0 VPWR VPWR x10_n17 sky130_fd_sc_hd__inv_1
X10_inv18 x10_n17 0 0 VPWR VPWR x10_n18 sky130_fd_sc_hd__inv_1
X10_inv19 x10_n18 0 0 VPWR VPWR x10_n19 sky130_fd_sc_hd__inv_1
X10_inv20 x10_n19 0 0 VPWR VPWR x10_n20 sky130_fd_sc_hd__inv_1
X10_inv21 x10_n20 0 0 VPWR VPWR x10_n21 sky130_fd_sc_hd__inv_1
X10_inv22 x10_n21 0 0 VPWR VPWR x10_n22 sky130_fd_sc_hd__inv_1
X10_inv23 x10_n22 0 0 VPWR VPWR x10_n23 sky130_fd_sc_hd__inv_1
X10_inv24 x10_n23 0 0 VPWR VPWR x10_n24 sky130_fd_sc_hd__inv_1
X10_inv25 x10_n24 0 0 VPWR VPWR x10_n25 sky130_fd_sc_hd__inv_1
X10_inv26 x10_n25 0 0 VPWR VPWR x10_n26 sky130_fd_sc_hd__inv_1
X10_inv27 x10_n26 0 0 VPWR VPWR x10_n27 sky130_fd_sc_hd__inv_1
X10_inv28 x10_n27 0 0 VPWR VPWR x10_n28 sky130_fd_sc_hd__inv_1
X10_inv29 x10_n28 0 0 VPWR VPWR x10_n29 sky130_fd_sc_hd__inv_1
X10_inv30 x10_n29 0 0 VPWR VPWR x10_n30 sky130_fd_sc_hd__inv_1
X10_buf x10_n15 0 0 VPWR VPWR x10_out sky130_fd_sc_hd__buf_1
* --- RO 11 ---
X11_nand EN x11_n30 0 0 VPWR VPWR x11_n0 sky130_fd_sc_hd__nand2_1
X11_inv1 x11_n0 0 0 VPWR VPWR x11_n1 sky130_fd_sc_hd__inv_1
X11_inv2 x11_n1 0 0 VPWR VPWR x11_n2 sky130_fd_sc_hd__inv_1
X11_inv3 x11_n2 0 0 VPWR VPWR x11_n3 sky130_fd_sc_hd__inv_1
X11_inv4 x11_n3 0 0 VPWR VPWR x11_n4 sky130_fd_sc_hd__inv_1
X11_inv5 x11_n4 0 0 VPWR VPWR x11_n5 sky130_fd_sc_hd__inv_1
X11_inv6 x11_n5 0 0 VPWR VPWR x11_n6 sky130_fd_sc_hd__inv_1
X11_inv7 x11_n6 0 0 VPWR VPWR x11_n7 sky130_fd_sc_hd__inv_1
X11_inv8 x11_n7 0 0 VPWR VPWR x11_n8 sky130_fd_sc_hd__inv_1
X11_inv9 x11_n8 0 0 VPWR VPWR x11_n9 sky130_fd_sc_hd__inv_1
X11_inv10 x11_n9 0 0 VPWR VPWR x11_n10 sky130_fd_sc_hd__inv_1
X11_inv11 x11_n10 0 0 VPWR VPWR x11_n11 sky130_fd_sc_hd__inv_1
X11_inv12 x11_n11 0 0 VPWR VPWR x11_n12 sky130_fd_sc_hd__inv_1
X11_inv13 x11_n12 0 0 VPWR VPWR x11_n13 sky130_fd_sc_hd__inv_1
X11_inv14 x11_n13 0 0 VPWR VPWR x11_n14 sky130_fd_sc_hd__inv_1
X11_inv15 x11_n14 0 0 VPWR VPWR x11_n15 sky130_fd_sc_hd__inv_1
X11_inv16 x11_n15 0 0 VPWR VPWR x11_n16 sky130_fd_sc_hd__inv_1
X11_inv17 x11_n16 0 0 VPWR VPWR x11_n17 sky130_fd_sc_hd__inv_1
X11_inv18 x11_n17 0 0 VPWR VPWR x11_n18 sky130_fd_sc_hd__inv_1
X11_inv19 x11_n18 0 0 VPWR VPWR x11_n19 sky130_fd_sc_hd__inv_1
X11_inv20 x11_n19 0 0 VPWR VPWR x11_n20 sky130_fd_sc_hd__inv_1
X11_inv21 x11_n20 0 0 VPWR VPWR x11_n21 sky130_fd_sc_hd__inv_1
X11_inv22 x11_n21 0 0 VPWR VPWR x11_n22 sky130_fd_sc_hd__inv_1
X11_inv23 x11_n22 0 0 VPWR VPWR x11_n23 sky130_fd_sc_hd__inv_1
X11_inv24 x11_n23 0 0 VPWR VPWR x11_n24 sky130_fd_sc_hd__inv_1
X11_inv25 x11_n24 0 0 VPWR VPWR x11_n25 sky130_fd_sc_hd__inv_1
X11_inv26 x11_n25 0 0 VPWR VPWR x11_n26 sky130_fd_sc_hd__inv_1
X11_inv27 x11_n26 0 0 VPWR VPWR x11_n27 sky130_fd_sc_hd__inv_1
X11_inv28 x11_n27 0 0 VPWR VPWR x11_n28 sky130_fd_sc_hd__inv_1
X11_inv29 x11_n28 0 0 VPWR VPWR x11_n29 sky130_fd_sc_hd__inv_1
X11_inv30 x11_n29 0 0 VPWR VPWR x11_n30 sky130_fd_sc_hd__inv_1
X11_buf x11_n15 0 0 VPWR VPWR x11_out sky130_fd_sc_hd__buf_1
* --- RO 12 ---
X12_nand EN x12_n30 0 0 VPWR VPWR x12_n0 sky130_fd_sc_hd__nand2_1
X12_inv1 x12_n0 0 0 VPWR VPWR x12_n1 sky130_fd_sc_hd__inv_1
X12_inv2 x12_n1 0 0 VPWR VPWR x12_n2 sky130_fd_sc_hd__inv_1
X12_inv3 x12_n2 0 0 VPWR VPWR x12_n3 sky130_fd_sc_hd__inv_1
X12_inv4 x12_n3 0 0 VPWR VPWR x12_n4 sky130_fd_sc_hd__inv_1
X12_inv5 x12_n4 0 0 VPWR VPWR x12_n5 sky130_fd_sc_hd__inv_1
X12_inv6 x12_n5 0 0 VPWR VPWR x12_n6 sky130_fd_sc_hd__inv_1
X12_inv7 x12_n6 0 0 VPWR VPWR x12_n7 sky130_fd_sc_hd__inv_1
X12_inv8 x12_n7 0 0 VPWR VPWR x12_n8 sky130_fd_sc_hd__inv_1
X12_inv9 x12_n8 0 0 VPWR VPWR x12_n9 sky130_fd_sc_hd__inv_1
X12_inv10 x12_n9 0 0 VPWR VPWR x12_n10 sky130_fd_sc_hd__inv_1
X12_inv11 x12_n10 0 0 VPWR VPWR x12_n11 sky130_fd_sc_hd__inv_1
X12_inv12 x12_n11 0 0 VPWR VPWR x12_n12 sky130_fd_sc_hd__inv_1
X12_inv13 x12_n12 0 0 VPWR VPWR x12_n13 sky130_fd_sc_hd__inv_1
X12_inv14 x12_n13 0 0 VPWR VPWR x12_n14 sky130_fd_sc_hd__inv_1
X12_inv15 x12_n14 0 0 VPWR VPWR x12_n15 sky130_fd_sc_hd__inv_1
X12_inv16 x12_n15 0 0 VPWR VPWR x12_n16 sky130_fd_sc_hd__inv_1
X12_inv17 x12_n16 0 0 VPWR VPWR x12_n17 sky130_fd_sc_hd__inv_1
X12_inv18 x12_n17 0 0 VPWR VPWR x12_n18 sky130_fd_sc_hd__inv_1
X12_inv19 x12_n18 0 0 VPWR VPWR x12_n19 sky130_fd_sc_hd__inv_1
X12_inv20 x12_n19 0 0 VPWR VPWR x12_n20 sky130_fd_sc_hd__inv_1
X12_inv21 x12_n20 0 0 VPWR VPWR x12_n21 sky130_fd_sc_hd__inv_1
X12_inv22 x12_n21 0 0 VPWR VPWR x12_n22 sky130_fd_sc_hd__inv_1
X12_inv23 x12_n22 0 0 VPWR VPWR x12_n23 sky130_fd_sc_hd__inv_1
X12_inv24 x12_n23 0 0 VPWR VPWR x12_n24 sky130_fd_sc_hd__inv_1
X12_inv25 x12_n24 0 0 VPWR VPWR x12_n25 sky130_fd_sc_hd__inv_1
X12_inv26 x12_n25 0 0 VPWR VPWR x12_n26 sky130_fd_sc_hd__inv_1
X12_inv27 x12_n26 0 0 VPWR VPWR x12_n27 sky130_fd_sc_hd__inv_1
X12_inv28 x12_n27 0 0 VPWR VPWR x12_n28 sky130_fd_sc_hd__inv_1
X12_inv29 x12_n28 0 0 VPWR VPWR x12_n29 sky130_fd_sc_hd__inv_1
X12_inv30 x12_n29 0 0 VPWR VPWR x12_n30 sky130_fd_sc_hd__inv_1
X12_buf x12_n15 0 0 VPWR VPWR x12_out sky130_fd_sc_hd__buf_1
* --- RO 13 ---
X13_nand EN x13_n30 0 0 VPWR VPWR x13_n0 sky130_fd_sc_hd__nand2_1
X13_inv1 x13_n0 0 0 VPWR VPWR x13_n1 sky130_fd_sc_hd__inv_1
X13_inv2 x13_n1 0 0 VPWR VPWR x13_n2 sky130_fd_sc_hd__inv_1
X13_inv3 x13_n2 0 0 VPWR VPWR x13_n3 sky130_fd_sc_hd__inv_1
X13_inv4 x13_n3 0 0 VPWR VPWR x13_n4 sky130_fd_sc_hd__inv_1
X13_inv5 x13_n4 0 0 VPWR VPWR x13_n5 sky130_fd_sc_hd__inv_1
X13_inv6 x13_n5 0 0 VPWR VPWR x13_n6 sky130_fd_sc_hd__inv_1
X13_inv7 x13_n6 0 0 VPWR VPWR x13_n7 sky130_fd_sc_hd__inv_1
X13_inv8 x13_n7 0 0 VPWR VPWR x13_n8 sky130_fd_sc_hd__inv_1
X13_inv9 x13_n8 0 0 VPWR VPWR x13_n9 sky130_fd_sc_hd__inv_1
X13_inv10 x13_n9 0 0 VPWR VPWR x13_n10 sky130_fd_sc_hd__inv_1
X13_inv11 x13_n10 0 0 VPWR VPWR x13_n11 sky130_fd_sc_hd__inv_1
X13_inv12 x13_n11 0 0 VPWR VPWR x13_n12 sky130_fd_sc_hd__inv_1
X13_inv13 x13_n12 0 0 VPWR VPWR x13_n13 sky130_fd_sc_hd__inv_1
X13_inv14 x13_n13 0 0 VPWR VPWR x13_n14 sky130_fd_sc_hd__inv_1
X13_inv15 x13_n14 0 0 VPWR VPWR x13_n15 sky130_fd_sc_hd__inv_1
X13_inv16 x13_n15 0 0 VPWR VPWR x13_n16 sky130_fd_sc_hd__inv_1
X13_inv17 x13_n16 0 0 VPWR VPWR x13_n17 sky130_fd_sc_hd__inv_1
X13_inv18 x13_n17 0 0 VPWR VPWR x13_n18 sky130_fd_sc_hd__inv_1
X13_inv19 x13_n18 0 0 VPWR VPWR x13_n19 sky130_fd_sc_hd__inv_1
X13_inv20 x13_n19 0 0 VPWR VPWR x13_n20 sky130_fd_sc_hd__inv_1
X13_inv21 x13_n20 0 0 VPWR VPWR x13_n21 sky130_fd_sc_hd__inv_1
X13_inv22 x13_n21 0 0 VPWR VPWR x13_n22 sky130_fd_sc_hd__inv_1
X13_inv23 x13_n22 0 0 VPWR VPWR x13_n23 sky130_fd_sc_hd__inv_1
X13_inv24 x13_n23 0 0 VPWR VPWR x13_n24 sky130_fd_sc_hd__inv_1
X13_inv25 x13_n24 0 0 VPWR VPWR x13_n25 sky130_fd_sc_hd__inv_1
X13_inv26 x13_n25 0 0 VPWR VPWR x13_n26 sky130_fd_sc_hd__inv_1
X13_inv27 x13_n26 0 0 VPWR VPWR x13_n27 sky130_fd_sc_hd__inv_1
X13_inv28 x13_n27 0 0 VPWR VPWR x13_n28 sky130_fd_sc_hd__inv_1
X13_inv29 x13_n28 0 0 VPWR VPWR x13_n29 sky130_fd_sc_hd__inv_1
X13_inv30 x13_n29 0 0 VPWR VPWR x13_n30 sky130_fd_sc_hd__inv_1
X13_buf x13_n15 0 0 VPWR VPWR x13_out sky130_fd_sc_hd__buf_1
* --- RO 14 ---
X14_nand EN x14_n30 0 0 VPWR VPWR x14_n0 sky130_fd_sc_hd__nand2_1
X14_inv1 x14_n0 0 0 VPWR VPWR x14_n1 sky130_fd_sc_hd__inv_1
X14_inv2 x14_n1 0 0 VPWR VPWR x14_n2 sky130_fd_sc_hd__inv_1
X14_inv3 x14_n2 0 0 VPWR VPWR x14_n3 sky130_fd_sc_hd__inv_1
X14_inv4 x14_n3 0 0 VPWR VPWR x14_n4 sky130_fd_sc_hd__inv_1
X14_inv5 x14_n4 0 0 VPWR VPWR x14_n5 sky130_fd_sc_hd__inv_1
X14_inv6 x14_n5 0 0 VPWR VPWR x14_n6 sky130_fd_sc_hd__inv_1
X14_inv7 x14_n6 0 0 VPWR VPWR x14_n7 sky130_fd_sc_hd__inv_1
X14_inv8 x14_n7 0 0 VPWR VPWR x14_n8 sky130_fd_sc_hd__inv_1
X14_inv9 x14_n8 0 0 VPWR VPWR x14_n9 sky130_fd_sc_hd__inv_1
X14_inv10 x14_n9 0 0 VPWR VPWR x14_n10 sky130_fd_sc_hd__inv_1
X14_inv11 x14_n10 0 0 VPWR VPWR x14_n11 sky130_fd_sc_hd__inv_1
X14_inv12 x14_n11 0 0 VPWR VPWR x14_n12 sky130_fd_sc_hd__inv_1
X14_inv13 x14_n12 0 0 VPWR VPWR x14_n13 sky130_fd_sc_hd__inv_1
X14_inv14 x14_n13 0 0 VPWR VPWR x14_n14 sky130_fd_sc_hd__inv_1
X14_inv15 x14_n14 0 0 VPWR VPWR x14_n15 sky130_fd_sc_hd__inv_1
X14_inv16 x14_n15 0 0 VPWR VPWR x14_n16 sky130_fd_sc_hd__inv_1
X14_inv17 x14_n16 0 0 VPWR VPWR x14_n17 sky130_fd_sc_hd__inv_1
X14_inv18 x14_n17 0 0 VPWR VPWR x14_n18 sky130_fd_sc_hd__inv_1
X14_inv19 x14_n18 0 0 VPWR VPWR x14_n19 sky130_fd_sc_hd__inv_1
X14_inv20 x14_n19 0 0 VPWR VPWR x14_n20 sky130_fd_sc_hd__inv_1
X14_inv21 x14_n20 0 0 VPWR VPWR x14_n21 sky130_fd_sc_hd__inv_1
X14_inv22 x14_n21 0 0 VPWR VPWR x14_n22 sky130_fd_sc_hd__inv_1
X14_inv23 x14_n22 0 0 VPWR VPWR x14_n23 sky130_fd_sc_hd__inv_1
X14_inv24 x14_n23 0 0 VPWR VPWR x14_n24 sky130_fd_sc_hd__inv_1
X14_inv25 x14_n24 0 0 VPWR VPWR x14_n25 sky130_fd_sc_hd__inv_1
X14_inv26 x14_n25 0 0 VPWR VPWR x14_n26 sky130_fd_sc_hd__inv_1
X14_inv27 x14_n26 0 0 VPWR VPWR x14_n27 sky130_fd_sc_hd__inv_1
X14_inv28 x14_n27 0 0 VPWR VPWR x14_n28 sky130_fd_sc_hd__inv_1
X14_inv29 x14_n28 0 0 VPWR VPWR x14_n29 sky130_fd_sc_hd__inv_1
X14_inv30 x14_n29 0 0 VPWR VPWR x14_n30 sky130_fd_sc_hd__inv_1
X14_buf x14_n15 0 0 VPWR VPWR x14_out sky130_fd_sc_hd__buf_1
* --- RO 15 ---
X15_nand EN x15_n30 0 0 VPWR VPWR x15_n0 sky130_fd_sc_hd__nand2_1
X15_inv1 x15_n0 0 0 VPWR VPWR x15_n1 sky130_fd_sc_hd__inv_1
X15_inv2 x15_n1 0 0 VPWR VPWR x15_n2 sky130_fd_sc_hd__inv_1
X15_inv3 x15_n2 0 0 VPWR VPWR x15_n3 sky130_fd_sc_hd__inv_1
X15_inv4 x15_n3 0 0 VPWR VPWR x15_n4 sky130_fd_sc_hd__inv_1
X15_inv5 x15_n4 0 0 VPWR VPWR x15_n5 sky130_fd_sc_hd__inv_1
X15_inv6 x15_n5 0 0 VPWR VPWR x15_n6 sky130_fd_sc_hd__inv_1
X15_inv7 x15_n6 0 0 VPWR VPWR x15_n7 sky130_fd_sc_hd__inv_1
X15_inv8 x15_n7 0 0 VPWR VPWR x15_n8 sky130_fd_sc_hd__inv_1
X15_inv9 x15_n8 0 0 VPWR VPWR x15_n9 sky130_fd_sc_hd__inv_1
X15_inv10 x15_n9 0 0 VPWR VPWR x15_n10 sky130_fd_sc_hd__inv_1
X15_inv11 x15_n10 0 0 VPWR VPWR x15_n11 sky130_fd_sc_hd__inv_1
X15_inv12 x15_n11 0 0 VPWR VPWR x15_n12 sky130_fd_sc_hd__inv_1
X15_inv13 x15_n12 0 0 VPWR VPWR x15_n13 sky130_fd_sc_hd__inv_1
X15_inv14 x15_n13 0 0 VPWR VPWR x15_n14 sky130_fd_sc_hd__inv_1
X15_inv15 x15_n14 0 0 VPWR VPWR x15_n15 sky130_fd_sc_hd__inv_1
X15_inv16 x15_n15 0 0 VPWR VPWR x15_n16 sky130_fd_sc_hd__inv_1
X15_inv17 x15_n16 0 0 VPWR VPWR x15_n17 sky130_fd_sc_hd__inv_1
X15_inv18 x15_n17 0 0 VPWR VPWR x15_n18 sky130_fd_sc_hd__inv_1
X15_inv19 x15_n18 0 0 VPWR VPWR x15_n19 sky130_fd_sc_hd__inv_1
X15_inv20 x15_n19 0 0 VPWR VPWR x15_n20 sky130_fd_sc_hd__inv_1
X15_inv21 x15_n20 0 0 VPWR VPWR x15_n21 sky130_fd_sc_hd__inv_1
X15_inv22 x15_n21 0 0 VPWR VPWR x15_n22 sky130_fd_sc_hd__inv_1
X15_inv23 x15_n22 0 0 VPWR VPWR x15_n23 sky130_fd_sc_hd__inv_1
X15_inv24 x15_n23 0 0 VPWR VPWR x15_n24 sky130_fd_sc_hd__inv_1
X15_inv25 x15_n24 0 0 VPWR VPWR x15_n25 sky130_fd_sc_hd__inv_1
X15_inv26 x15_n25 0 0 VPWR VPWR x15_n26 sky130_fd_sc_hd__inv_1
X15_inv27 x15_n26 0 0 VPWR VPWR x15_n27 sky130_fd_sc_hd__inv_1
X15_inv28 x15_n27 0 0 VPWR VPWR x15_n28 sky130_fd_sc_hd__inv_1
X15_inv29 x15_n28 0 0 VPWR VPWR x15_n29 sky130_fd_sc_hd__inv_1
X15_inv30 x15_n29 0 0 VPWR VPWR x15_n30 sky130_fd_sc_hd__inv_1
X15_buf x15_n15 0 0 VPWR VPWR x15_out sky130_fd_sc_hd__buf_1
* --- RO 16 ---
X16_nand EN x16_n30 0 0 VPWR VPWR x16_n0 sky130_fd_sc_hd__nand2_1
X16_inv1 x16_n0 0 0 VPWR VPWR x16_n1 sky130_fd_sc_hd__inv_1
X16_inv2 x16_n1 0 0 VPWR VPWR x16_n2 sky130_fd_sc_hd__inv_1
X16_inv3 x16_n2 0 0 VPWR VPWR x16_n3 sky130_fd_sc_hd__inv_1
X16_inv4 x16_n3 0 0 VPWR VPWR x16_n4 sky130_fd_sc_hd__inv_1
X16_inv5 x16_n4 0 0 VPWR VPWR x16_n5 sky130_fd_sc_hd__inv_1
X16_inv6 x16_n5 0 0 VPWR VPWR x16_n6 sky130_fd_sc_hd__inv_1
X16_inv7 x16_n6 0 0 VPWR VPWR x16_n7 sky130_fd_sc_hd__inv_1
X16_inv8 x16_n7 0 0 VPWR VPWR x16_n8 sky130_fd_sc_hd__inv_1
X16_inv9 x16_n8 0 0 VPWR VPWR x16_n9 sky130_fd_sc_hd__inv_1
X16_inv10 x16_n9 0 0 VPWR VPWR x16_n10 sky130_fd_sc_hd__inv_1
X16_inv11 x16_n10 0 0 VPWR VPWR x16_n11 sky130_fd_sc_hd__inv_1
X16_inv12 x16_n11 0 0 VPWR VPWR x16_n12 sky130_fd_sc_hd__inv_1
X16_inv13 x16_n12 0 0 VPWR VPWR x16_n13 sky130_fd_sc_hd__inv_1
X16_inv14 x16_n13 0 0 VPWR VPWR x16_n14 sky130_fd_sc_hd__inv_1
X16_inv15 x16_n14 0 0 VPWR VPWR x16_n15 sky130_fd_sc_hd__inv_1
X16_inv16 x16_n15 0 0 VPWR VPWR x16_n16 sky130_fd_sc_hd__inv_1
X16_inv17 x16_n16 0 0 VPWR VPWR x16_n17 sky130_fd_sc_hd__inv_1
X16_inv18 x16_n17 0 0 VPWR VPWR x16_n18 sky130_fd_sc_hd__inv_1
X16_inv19 x16_n18 0 0 VPWR VPWR x16_n19 sky130_fd_sc_hd__inv_1
X16_inv20 x16_n19 0 0 VPWR VPWR x16_n20 sky130_fd_sc_hd__inv_1
X16_inv21 x16_n20 0 0 VPWR VPWR x16_n21 sky130_fd_sc_hd__inv_1
X16_inv22 x16_n21 0 0 VPWR VPWR x16_n22 sky130_fd_sc_hd__inv_1
X16_inv23 x16_n22 0 0 VPWR VPWR x16_n23 sky130_fd_sc_hd__inv_1
X16_inv24 x16_n23 0 0 VPWR VPWR x16_n24 sky130_fd_sc_hd__inv_1
X16_inv25 x16_n24 0 0 VPWR VPWR x16_n25 sky130_fd_sc_hd__inv_1
X16_inv26 x16_n25 0 0 VPWR VPWR x16_n26 sky130_fd_sc_hd__inv_1
X16_inv27 x16_n26 0 0 VPWR VPWR x16_n27 sky130_fd_sc_hd__inv_1
X16_inv28 x16_n27 0 0 VPWR VPWR x16_n28 sky130_fd_sc_hd__inv_1
X16_inv29 x16_n28 0 0 VPWR VPWR x16_n29 sky130_fd_sc_hd__inv_1
X16_inv30 x16_n29 0 0 VPWR VPWR x16_n30 sky130_fd_sc_hd__inv_1
X16_buf x16_n15 0 0 VPWR VPWR x16_out sky130_fd_sc_hd__buf_1
* --- RO 17 ---
X17_nand EN x17_n30 0 0 VPWR VPWR x17_n0 sky130_fd_sc_hd__nand2_1
X17_inv1 x17_n0 0 0 VPWR VPWR x17_n1 sky130_fd_sc_hd__inv_1
X17_inv2 x17_n1 0 0 VPWR VPWR x17_n2 sky130_fd_sc_hd__inv_1
X17_inv3 x17_n2 0 0 VPWR VPWR x17_n3 sky130_fd_sc_hd__inv_1
X17_inv4 x17_n3 0 0 VPWR VPWR x17_n4 sky130_fd_sc_hd__inv_1
X17_inv5 x17_n4 0 0 VPWR VPWR x17_n5 sky130_fd_sc_hd__inv_1
X17_inv6 x17_n5 0 0 VPWR VPWR x17_n6 sky130_fd_sc_hd__inv_1
X17_inv7 x17_n6 0 0 VPWR VPWR x17_n7 sky130_fd_sc_hd__inv_1
X17_inv8 x17_n7 0 0 VPWR VPWR x17_n8 sky130_fd_sc_hd__inv_1
X17_inv9 x17_n8 0 0 VPWR VPWR x17_n9 sky130_fd_sc_hd__inv_1
X17_inv10 x17_n9 0 0 VPWR VPWR x17_n10 sky130_fd_sc_hd__inv_1
X17_inv11 x17_n10 0 0 VPWR VPWR x17_n11 sky130_fd_sc_hd__inv_1
X17_inv12 x17_n11 0 0 VPWR VPWR x17_n12 sky130_fd_sc_hd__inv_1
X17_inv13 x17_n12 0 0 VPWR VPWR x17_n13 sky130_fd_sc_hd__inv_1
X17_inv14 x17_n13 0 0 VPWR VPWR x17_n14 sky130_fd_sc_hd__inv_1
X17_inv15 x17_n14 0 0 VPWR VPWR x17_n15 sky130_fd_sc_hd__inv_1
X17_inv16 x17_n15 0 0 VPWR VPWR x17_n16 sky130_fd_sc_hd__inv_1
X17_inv17 x17_n16 0 0 VPWR VPWR x17_n17 sky130_fd_sc_hd__inv_1
X17_inv18 x17_n17 0 0 VPWR VPWR x17_n18 sky130_fd_sc_hd__inv_1
X17_inv19 x17_n18 0 0 VPWR VPWR x17_n19 sky130_fd_sc_hd__inv_1
X17_inv20 x17_n19 0 0 VPWR VPWR x17_n20 sky130_fd_sc_hd__inv_1
X17_inv21 x17_n20 0 0 VPWR VPWR x17_n21 sky130_fd_sc_hd__inv_1
X17_inv22 x17_n21 0 0 VPWR VPWR x17_n22 sky130_fd_sc_hd__inv_1
X17_inv23 x17_n22 0 0 VPWR VPWR x17_n23 sky130_fd_sc_hd__inv_1
X17_inv24 x17_n23 0 0 VPWR VPWR x17_n24 sky130_fd_sc_hd__inv_1
X17_inv25 x17_n24 0 0 VPWR VPWR x17_n25 sky130_fd_sc_hd__inv_1
X17_inv26 x17_n25 0 0 VPWR VPWR x17_n26 sky130_fd_sc_hd__inv_1
X17_inv27 x17_n26 0 0 VPWR VPWR x17_n27 sky130_fd_sc_hd__inv_1
X17_inv28 x17_n27 0 0 VPWR VPWR x17_n28 sky130_fd_sc_hd__inv_1
X17_inv29 x17_n28 0 0 VPWR VPWR x17_n29 sky130_fd_sc_hd__inv_1
X17_inv30 x17_n29 0 0 VPWR VPWR x17_n30 sky130_fd_sc_hd__inv_1
X17_buf x17_n15 0 0 VPWR VPWR x17_out sky130_fd_sc_hd__buf_1
* --- RO 18 ---
X18_nand EN x18_n30 0 0 VPWR VPWR x18_n0 sky130_fd_sc_hd__nand2_1
X18_inv1 x18_n0 0 0 VPWR VPWR x18_n1 sky130_fd_sc_hd__inv_1
X18_inv2 x18_n1 0 0 VPWR VPWR x18_n2 sky130_fd_sc_hd__inv_1
X18_inv3 x18_n2 0 0 VPWR VPWR x18_n3 sky130_fd_sc_hd__inv_1
X18_inv4 x18_n3 0 0 VPWR VPWR x18_n4 sky130_fd_sc_hd__inv_1
X18_inv5 x18_n4 0 0 VPWR VPWR x18_n5 sky130_fd_sc_hd__inv_1
X18_inv6 x18_n5 0 0 VPWR VPWR x18_n6 sky130_fd_sc_hd__inv_1
X18_inv7 x18_n6 0 0 VPWR VPWR x18_n7 sky130_fd_sc_hd__inv_1
X18_inv8 x18_n7 0 0 VPWR VPWR x18_n8 sky130_fd_sc_hd__inv_1
X18_inv9 x18_n8 0 0 VPWR VPWR x18_n9 sky130_fd_sc_hd__inv_1
X18_inv10 x18_n9 0 0 VPWR VPWR x18_n10 sky130_fd_sc_hd__inv_1
X18_inv11 x18_n10 0 0 VPWR VPWR x18_n11 sky130_fd_sc_hd__inv_1
X18_inv12 x18_n11 0 0 VPWR VPWR x18_n12 sky130_fd_sc_hd__inv_1
X18_inv13 x18_n12 0 0 VPWR VPWR x18_n13 sky130_fd_sc_hd__inv_1
X18_inv14 x18_n13 0 0 VPWR VPWR x18_n14 sky130_fd_sc_hd__inv_1
X18_inv15 x18_n14 0 0 VPWR VPWR x18_n15 sky130_fd_sc_hd__inv_1
X18_inv16 x18_n15 0 0 VPWR VPWR x18_n16 sky130_fd_sc_hd__inv_1
X18_inv17 x18_n16 0 0 VPWR VPWR x18_n17 sky130_fd_sc_hd__inv_1
X18_inv18 x18_n17 0 0 VPWR VPWR x18_n18 sky130_fd_sc_hd__inv_1
X18_inv19 x18_n18 0 0 VPWR VPWR x18_n19 sky130_fd_sc_hd__inv_1
X18_inv20 x18_n19 0 0 VPWR VPWR x18_n20 sky130_fd_sc_hd__inv_1
X18_inv21 x18_n20 0 0 VPWR VPWR x18_n21 sky130_fd_sc_hd__inv_1
X18_inv22 x18_n21 0 0 VPWR VPWR x18_n22 sky130_fd_sc_hd__inv_1
X18_inv23 x18_n22 0 0 VPWR VPWR x18_n23 sky130_fd_sc_hd__inv_1
X18_inv24 x18_n23 0 0 VPWR VPWR x18_n24 sky130_fd_sc_hd__inv_1
X18_inv25 x18_n24 0 0 VPWR VPWR x18_n25 sky130_fd_sc_hd__inv_1
X18_inv26 x18_n25 0 0 VPWR VPWR x18_n26 sky130_fd_sc_hd__inv_1
X18_inv27 x18_n26 0 0 VPWR VPWR x18_n27 sky130_fd_sc_hd__inv_1
X18_inv28 x18_n27 0 0 VPWR VPWR x18_n28 sky130_fd_sc_hd__inv_1
X18_inv29 x18_n28 0 0 VPWR VPWR x18_n29 sky130_fd_sc_hd__inv_1
X18_inv30 x18_n29 0 0 VPWR VPWR x18_n30 sky130_fd_sc_hd__inv_1
X18_buf x18_n15 0 0 VPWR VPWR x18_out sky130_fd_sc_hd__buf_1
* --- RO 19 ---
X19_nand EN x19_n30 0 0 VPWR VPWR x19_n0 sky130_fd_sc_hd__nand2_1
X19_inv1 x19_n0 0 0 VPWR VPWR x19_n1 sky130_fd_sc_hd__inv_1
X19_inv2 x19_n1 0 0 VPWR VPWR x19_n2 sky130_fd_sc_hd__inv_1
X19_inv3 x19_n2 0 0 VPWR VPWR x19_n3 sky130_fd_sc_hd__inv_1
X19_inv4 x19_n3 0 0 VPWR VPWR x19_n4 sky130_fd_sc_hd__inv_1
X19_inv5 x19_n4 0 0 VPWR VPWR x19_n5 sky130_fd_sc_hd__inv_1
X19_inv6 x19_n5 0 0 VPWR VPWR x19_n6 sky130_fd_sc_hd__inv_1
X19_inv7 x19_n6 0 0 VPWR VPWR x19_n7 sky130_fd_sc_hd__inv_1
X19_inv8 x19_n7 0 0 VPWR VPWR x19_n8 sky130_fd_sc_hd__inv_1
X19_inv9 x19_n8 0 0 VPWR VPWR x19_n9 sky130_fd_sc_hd__inv_1
X19_inv10 x19_n9 0 0 VPWR VPWR x19_n10 sky130_fd_sc_hd__inv_1
X19_inv11 x19_n10 0 0 VPWR VPWR x19_n11 sky130_fd_sc_hd__inv_1
X19_inv12 x19_n11 0 0 VPWR VPWR x19_n12 sky130_fd_sc_hd__inv_1
X19_inv13 x19_n12 0 0 VPWR VPWR x19_n13 sky130_fd_sc_hd__inv_1
X19_inv14 x19_n13 0 0 VPWR VPWR x19_n14 sky130_fd_sc_hd__inv_1
X19_inv15 x19_n14 0 0 VPWR VPWR x19_n15 sky130_fd_sc_hd__inv_1
X19_inv16 x19_n15 0 0 VPWR VPWR x19_n16 sky130_fd_sc_hd__inv_1
X19_inv17 x19_n16 0 0 VPWR VPWR x19_n17 sky130_fd_sc_hd__inv_1
X19_inv18 x19_n17 0 0 VPWR VPWR x19_n18 sky130_fd_sc_hd__inv_1
X19_inv19 x19_n18 0 0 VPWR VPWR x19_n19 sky130_fd_sc_hd__inv_1
X19_inv20 x19_n19 0 0 VPWR VPWR x19_n20 sky130_fd_sc_hd__inv_1
X19_inv21 x19_n20 0 0 VPWR VPWR x19_n21 sky130_fd_sc_hd__inv_1
X19_inv22 x19_n21 0 0 VPWR VPWR x19_n22 sky130_fd_sc_hd__inv_1
X19_inv23 x19_n22 0 0 VPWR VPWR x19_n23 sky130_fd_sc_hd__inv_1
X19_inv24 x19_n23 0 0 VPWR VPWR x19_n24 sky130_fd_sc_hd__inv_1
X19_inv25 x19_n24 0 0 VPWR VPWR x19_n25 sky130_fd_sc_hd__inv_1
X19_inv26 x19_n25 0 0 VPWR VPWR x19_n26 sky130_fd_sc_hd__inv_1
X19_inv27 x19_n26 0 0 VPWR VPWR x19_n27 sky130_fd_sc_hd__inv_1
X19_inv28 x19_n27 0 0 VPWR VPWR x19_n28 sky130_fd_sc_hd__inv_1
X19_inv29 x19_n28 0 0 VPWR VPWR x19_n29 sky130_fd_sc_hd__inv_1
X19_inv30 x19_n29 0 0 VPWR VPWR x19_n30 sky130_fd_sc_hd__inv_1
X19_buf x19_n15 0 0 VPWR VPWR x19_out sky130_fd_sc_hd__buf_1
* --- RO 20 ---
X20_nand EN x20_n30 0 0 VPWR VPWR x20_n0 sky130_fd_sc_hd__nand2_1
X20_inv1 x20_n0 0 0 VPWR VPWR x20_n1 sky130_fd_sc_hd__inv_1
X20_inv2 x20_n1 0 0 VPWR VPWR x20_n2 sky130_fd_sc_hd__inv_1
X20_inv3 x20_n2 0 0 VPWR VPWR x20_n3 sky130_fd_sc_hd__inv_1
X20_inv4 x20_n3 0 0 VPWR VPWR x20_n4 sky130_fd_sc_hd__inv_1
X20_inv5 x20_n4 0 0 VPWR VPWR x20_n5 sky130_fd_sc_hd__inv_1
X20_inv6 x20_n5 0 0 VPWR VPWR x20_n6 sky130_fd_sc_hd__inv_1
X20_inv7 x20_n6 0 0 VPWR VPWR x20_n7 sky130_fd_sc_hd__inv_1
X20_inv8 x20_n7 0 0 VPWR VPWR x20_n8 sky130_fd_sc_hd__inv_1
X20_inv9 x20_n8 0 0 VPWR VPWR x20_n9 sky130_fd_sc_hd__inv_1
X20_inv10 x20_n9 0 0 VPWR VPWR x20_n10 sky130_fd_sc_hd__inv_1
X20_inv11 x20_n10 0 0 VPWR VPWR x20_n11 sky130_fd_sc_hd__inv_1
X20_inv12 x20_n11 0 0 VPWR VPWR x20_n12 sky130_fd_sc_hd__inv_1
X20_inv13 x20_n12 0 0 VPWR VPWR x20_n13 sky130_fd_sc_hd__inv_1
X20_inv14 x20_n13 0 0 VPWR VPWR x20_n14 sky130_fd_sc_hd__inv_1
X20_inv15 x20_n14 0 0 VPWR VPWR x20_n15 sky130_fd_sc_hd__inv_1
X20_inv16 x20_n15 0 0 VPWR VPWR x20_n16 sky130_fd_sc_hd__inv_1
X20_inv17 x20_n16 0 0 VPWR VPWR x20_n17 sky130_fd_sc_hd__inv_1
X20_inv18 x20_n17 0 0 VPWR VPWR x20_n18 sky130_fd_sc_hd__inv_1
X20_inv19 x20_n18 0 0 VPWR VPWR x20_n19 sky130_fd_sc_hd__inv_1
X20_inv20 x20_n19 0 0 VPWR VPWR x20_n20 sky130_fd_sc_hd__inv_1
X20_inv21 x20_n20 0 0 VPWR VPWR x20_n21 sky130_fd_sc_hd__inv_1
X20_inv22 x20_n21 0 0 VPWR VPWR x20_n22 sky130_fd_sc_hd__inv_1
X20_inv23 x20_n22 0 0 VPWR VPWR x20_n23 sky130_fd_sc_hd__inv_1
X20_inv24 x20_n23 0 0 VPWR VPWR x20_n24 sky130_fd_sc_hd__inv_1
X20_inv25 x20_n24 0 0 VPWR VPWR x20_n25 sky130_fd_sc_hd__inv_1
X20_inv26 x20_n25 0 0 VPWR VPWR x20_n26 sky130_fd_sc_hd__inv_1
X20_inv27 x20_n26 0 0 VPWR VPWR x20_n27 sky130_fd_sc_hd__inv_1
X20_inv28 x20_n27 0 0 VPWR VPWR x20_n28 sky130_fd_sc_hd__inv_1
X20_inv29 x20_n28 0 0 VPWR VPWR x20_n29 sky130_fd_sc_hd__inv_1
X20_inv30 x20_n29 0 0 VPWR VPWR x20_n30 sky130_fd_sc_hd__inv_1
X20_buf x20_n15 0 0 VPWR VPWR x20_out sky130_fd_sc_hd__buf_1
* --- RO 21 ---
X21_nand EN x21_n30 0 0 VPWR VPWR x21_n0 sky130_fd_sc_hd__nand2_1
X21_inv1 x21_n0 0 0 VPWR VPWR x21_n1 sky130_fd_sc_hd__inv_1
X21_inv2 x21_n1 0 0 VPWR VPWR x21_n2 sky130_fd_sc_hd__inv_1
X21_inv3 x21_n2 0 0 VPWR VPWR x21_n3 sky130_fd_sc_hd__inv_1
X21_inv4 x21_n3 0 0 VPWR VPWR x21_n4 sky130_fd_sc_hd__inv_1
X21_inv5 x21_n4 0 0 VPWR VPWR x21_n5 sky130_fd_sc_hd__inv_1
X21_inv6 x21_n5 0 0 VPWR VPWR x21_n6 sky130_fd_sc_hd__inv_1
X21_inv7 x21_n6 0 0 VPWR VPWR x21_n7 sky130_fd_sc_hd__inv_1
X21_inv8 x21_n7 0 0 VPWR VPWR x21_n8 sky130_fd_sc_hd__inv_1
X21_inv9 x21_n8 0 0 VPWR VPWR x21_n9 sky130_fd_sc_hd__inv_1
X21_inv10 x21_n9 0 0 VPWR VPWR x21_n10 sky130_fd_sc_hd__inv_1
X21_inv11 x21_n10 0 0 VPWR VPWR x21_n11 sky130_fd_sc_hd__inv_1
X21_inv12 x21_n11 0 0 VPWR VPWR x21_n12 sky130_fd_sc_hd__inv_1
X21_inv13 x21_n12 0 0 VPWR VPWR x21_n13 sky130_fd_sc_hd__inv_1
X21_inv14 x21_n13 0 0 VPWR VPWR x21_n14 sky130_fd_sc_hd__inv_1
X21_inv15 x21_n14 0 0 VPWR VPWR x21_n15 sky130_fd_sc_hd__inv_1
X21_inv16 x21_n15 0 0 VPWR VPWR x21_n16 sky130_fd_sc_hd__inv_1
X21_inv17 x21_n16 0 0 VPWR VPWR x21_n17 sky130_fd_sc_hd__inv_1
X21_inv18 x21_n17 0 0 VPWR VPWR x21_n18 sky130_fd_sc_hd__inv_1
X21_inv19 x21_n18 0 0 VPWR VPWR x21_n19 sky130_fd_sc_hd__inv_1
X21_inv20 x21_n19 0 0 VPWR VPWR x21_n20 sky130_fd_sc_hd__inv_1
X21_inv21 x21_n20 0 0 VPWR VPWR x21_n21 sky130_fd_sc_hd__inv_1
X21_inv22 x21_n21 0 0 VPWR VPWR x21_n22 sky130_fd_sc_hd__inv_1
X21_inv23 x21_n22 0 0 VPWR VPWR x21_n23 sky130_fd_sc_hd__inv_1
X21_inv24 x21_n23 0 0 VPWR VPWR x21_n24 sky130_fd_sc_hd__inv_1
X21_inv25 x21_n24 0 0 VPWR VPWR x21_n25 sky130_fd_sc_hd__inv_1
X21_inv26 x21_n25 0 0 VPWR VPWR x21_n26 sky130_fd_sc_hd__inv_1
X21_inv27 x21_n26 0 0 VPWR VPWR x21_n27 sky130_fd_sc_hd__inv_1
X21_inv28 x21_n27 0 0 VPWR VPWR x21_n28 sky130_fd_sc_hd__inv_1
X21_inv29 x21_n28 0 0 VPWR VPWR x21_n29 sky130_fd_sc_hd__inv_1
X21_inv30 x21_n29 0 0 VPWR VPWR x21_n30 sky130_fd_sc_hd__inv_1
X21_buf x21_n15 0 0 VPWR VPWR x21_out sky130_fd_sc_hd__buf_1
* --- RO 22 ---
X22_nand EN x22_n30 0 0 VPWR VPWR x22_n0 sky130_fd_sc_hd__nand2_1
X22_inv1 x22_n0 0 0 VPWR VPWR x22_n1 sky130_fd_sc_hd__inv_1
X22_inv2 x22_n1 0 0 VPWR VPWR x22_n2 sky130_fd_sc_hd__inv_1
X22_inv3 x22_n2 0 0 VPWR VPWR x22_n3 sky130_fd_sc_hd__inv_1
X22_inv4 x22_n3 0 0 VPWR VPWR x22_n4 sky130_fd_sc_hd__inv_1
X22_inv5 x22_n4 0 0 VPWR VPWR x22_n5 sky130_fd_sc_hd__inv_1
X22_inv6 x22_n5 0 0 VPWR VPWR x22_n6 sky130_fd_sc_hd__inv_1
X22_inv7 x22_n6 0 0 VPWR VPWR x22_n7 sky130_fd_sc_hd__inv_1
X22_inv8 x22_n7 0 0 VPWR VPWR x22_n8 sky130_fd_sc_hd__inv_1
X22_inv9 x22_n8 0 0 VPWR VPWR x22_n9 sky130_fd_sc_hd__inv_1
X22_inv10 x22_n9 0 0 VPWR VPWR x22_n10 sky130_fd_sc_hd__inv_1
X22_inv11 x22_n10 0 0 VPWR VPWR x22_n11 sky130_fd_sc_hd__inv_1
X22_inv12 x22_n11 0 0 VPWR VPWR x22_n12 sky130_fd_sc_hd__inv_1
X22_inv13 x22_n12 0 0 VPWR VPWR x22_n13 sky130_fd_sc_hd__inv_1
X22_inv14 x22_n13 0 0 VPWR VPWR x22_n14 sky130_fd_sc_hd__inv_1
X22_inv15 x22_n14 0 0 VPWR VPWR x22_n15 sky130_fd_sc_hd__inv_1
X22_inv16 x22_n15 0 0 VPWR VPWR x22_n16 sky130_fd_sc_hd__inv_1
X22_inv17 x22_n16 0 0 VPWR VPWR x22_n17 sky130_fd_sc_hd__inv_1
X22_inv18 x22_n17 0 0 VPWR VPWR x22_n18 sky130_fd_sc_hd__inv_1
X22_inv19 x22_n18 0 0 VPWR VPWR x22_n19 sky130_fd_sc_hd__inv_1
X22_inv20 x22_n19 0 0 VPWR VPWR x22_n20 sky130_fd_sc_hd__inv_1
X22_inv21 x22_n20 0 0 VPWR VPWR x22_n21 sky130_fd_sc_hd__inv_1
X22_inv22 x22_n21 0 0 VPWR VPWR x22_n22 sky130_fd_sc_hd__inv_1
X22_inv23 x22_n22 0 0 VPWR VPWR x22_n23 sky130_fd_sc_hd__inv_1
X22_inv24 x22_n23 0 0 VPWR VPWR x22_n24 sky130_fd_sc_hd__inv_1
X22_inv25 x22_n24 0 0 VPWR VPWR x22_n25 sky130_fd_sc_hd__inv_1
X22_inv26 x22_n25 0 0 VPWR VPWR x22_n26 sky130_fd_sc_hd__inv_1
X22_inv27 x22_n26 0 0 VPWR VPWR x22_n27 sky130_fd_sc_hd__inv_1
X22_inv28 x22_n27 0 0 VPWR VPWR x22_n28 sky130_fd_sc_hd__inv_1
X22_inv29 x22_n28 0 0 VPWR VPWR x22_n29 sky130_fd_sc_hd__inv_1
X22_inv30 x22_n29 0 0 VPWR VPWR x22_n30 sky130_fd_sc_hd__inv_1
X22_buf x22_n15 0 0 VPWR VPWR x22_out sky130_fd_sc_hd__buf_1
* --- RO 23 ---
X23_nand EN x23_n30 0 0 VPWR VPWR x23_n0 sky130_fd_sc_hd__nand2_1
X23_inv1 x23_n0 0 0 VPWR VPWR x23_n1 sky130_fd_sc_hd__inv_1
X23_inv2 x23_n1 0 0 VPWR VPWR x23_n2 sky130_fd_sc_hd__inv_1
X23_inv3 x23_n2 0 0 VPWR VPWR x23_n3 sky130_fd_sc_hd__inv_1
X23_inv4 x23_n3 0 0 VPWR VPWR x23_n4 sky130_fd_sc_hd__inv_1
X23_inv5 x23_n4 0 0 VPWR VPWR x23_n5 sky130_fd_sc_hd__inv_1
X23_inv6 x23_n5 0 0 VPWR VPWR x23_n6 sky130_fd_sc_hd__inv_1
X23_inv7 x23_n6 0 0 VPWR VPWR x23_n7 sky130_fd_sc_hd__inv_1
X23_inv8 x23_n7 0 0 VPWR VPWR x23_n8 sky130_fd_sc_hd__inv_1
X23_inv9 x23_n8 0 0 VPWR VPWR x23_n9 sky130_fd_sc_hd__inv_1
X23_inv10 x23_n9 0 0 VPWR VPWR x23_n10 sky130_fd_sc_hd__inv_1
X23_inv11 x23_n10 0 0 VPWR VPWR x23_n11 sky130_fd_sc_hd__inv_1
X23_inv12 x23_n11 0 0 VPWR VPWR x23_n12 sky130_fd_sc_hd__inv_1
X23_inv13 x23_n12 0 0 VPWR VPWR x23_n13 sky130_fd_sc_hd__inv_1
X23_inv14 x23_n13 0 0 VPWR VPWR x23_n14 sky130_fd_sc_hd__inv_1
X23_inv15 x23_n14 0 0 VPWR VPWR x23_n15 sky130_fd_sc_hd__inv_1
X23_inv16 x23_n15 0 0 VPWR VPWR x23_n16 sky130_fd_sc_hd__inv_1
X23_inv17 x23_n16 0 0 VPWR VPWR x23_n17 sky130_fd_sc_hd__inv_1
X23_inv18 x23_n17 0 0 VPWR VPWR x23_n18 sky130_fd_sc_hd__inv_1
X23_inv19 x23_n18 0 0 VPWR VPWR x23_n19 sky130_fd_sc_hd__inv_1
X23_inv20 x23_n19 0 0 VPWR VPWR x23_n20 sky130_fd_sc_hd__inv_1
X23_inv21 x23_n20 0 0 VPWR VPWR x23_n21 sky130_fd_sc_hd__inv_1
X23_inv22 x23_n21 0 0 VPWR VPWR x23_n22 sky130_fd_sc_hd__inv_1
X23_inv23 x23_n22 0 0 VPWR VPWR x23_n23 sky130_fd_sc_hd__inv_1
X23_inv24 x23_n23 0 0 VPWR VPWR x23_n24 sky130_fd_sc_hd__inv_1
X23_inv25 x23_n24 0 0 VPWR VPWR x23_n25 sky130_fd_sc_hd__inv_1
X23_inv26 x23_n25 0 0 VPWR VPWR x23_n26 sky130_fd_sc_hd__inv_1
X23_inv27 x23_n26 0 0 VPWR VPWR x23_n27 sky130_fd_sc_hd__inv_1
X23_inv28 x23_n27 0 0 VPWR VPWR x23_n28 sky130_fd_sc_hd__inv_1
X23_inv29 x23_n28 0 0 VPWR VPWR x23_n29 sky130_fd_sc_hd__inv_1
X23_inv30 x23_n29 0 0 VPWR VPWR x23_n30 sky130_fd_sc_hd__inv_1
X23_buf x23_n15 0 0 VPWR VPWR x23_out sky130_fd_sc_hd__buf_1
* --- RO 24 ---
X24_nand EN x24_n30 0 0 VPWR VPWR x24_n0 sky130_fd_sc_hd__nand2_1
X24_inv1 x24_n0 0 0 VPWR VPWR x24_n1 sky130_fd_sc_hd__inv_1
X24_inv2 x24_n1 0 0 VPWR VPWR x24_n2 sky130_fd_sc_hd__inv_1
X24_inv3 x24_n2 0 0 VPWR VPWR x24_n3 sky130_fd_sc_hd__inv_1
X24_inv4 x24_n3 0 0 VPWR VPWR x24_n4 sky130_fd_sc_hd__inv_1
X24_inv5 x24_n4 0 0 VPWR VPWR x24_n5 sky130_fd_sc_hd__inv_1
X24_inv6 x24_n5 0 0 VPWR VPWR x24_n6 sky130_fd_sc_hd__inv_1
X24_inv7 x24_n6 0 0 VPWR VPWR x24_n7 sky130_fd_sc_hd__inv_1
X24_inv8 x24_n7 0 0 VPWR VPWR x24_n8 sky130_fd_sc_hd__inv_1
X24_inv9 x24_n8 0 0 VPWR VPWR x24_n9 sky130_fd_sc_hd__inv_1
X24_inv10 x24_n9 0 0 VPWR VPWR x24_n10 sky130_fd_sc_hd__inv_1
X24_inv11 x24_n10 0 0 VPWR VPWR x24_n11 sky130_fd_sc_hd__inv_1
X24_inv12 x24_n11 0 0 VPWR VPWR x24_n12 sky130_fd_sc_hd__inv_1
X24_inv13 x24_n12 0 0 VPWR VPWR x24_n13 sky130_fd_sc_hd__inv_1
X24_inv14 x24_n13 0 0 VPWR VPWR x24_n14 sky130_fd_sc_hd__inv_1
X24_inv15 x24_n14 0 0 VPWR VPWR x24_n15 sky130_fd_sc_hd__inv_1
X24_inv16 x24_n15 0 0 VPWR VPWR x24_n16 sky130_fd_sc_hd__inv_1
X24_inv17 x24_n16 0 0 VPWR VPWR x24_n17 sky130_fd_sc_hd__inv_1
X24_inv18 x24_n17 0 0 VPWR VPWR x24_n18 sky130_fd_sc_hd__inv_1
X24_inv19 x24_n18 0 0 VPWR VPWR x24_n19 sky130_fd_sc_hd__inv_1
X24_inv20 x24_n19 0 0 VPWR VPWR x24_n20 sky130_fd_sc_hd__inv_1
X24_inv21 x24_n20 0 0 VPWR VPWR x24_n21 sky130_fd_sc_hd__inv_1
X24_inv22 x24_n21 0 0 VPWR VPWR x24_n22 sky130_fd_sc_hd__inv_1
X24_inv23 x24_n22 0 0 VPWR VPWR x24_n23 sky130_fd_sc_hd__inv_1
X24_inv24 x24_n23 0 0 VPWR VPWR x24_n24 sky130_fd_sc_hd__inv_1
X24_inv25 x24_n24 0 0 VPWR VPWR x24_n25 sky130_fd_sc_hd__inv_1
X24_inv26 x24_n25 0 0 VPWR VPWR x24_n26 sky130_fd_sc_hd__inv_1
X24_inv27 x24_n26 0 0 VPWR VPWR x24_n27 sky130_fd_sc_hd__inv_1
X24_inv28 x24_n27 0 0 VPWR VPWR x24_n28 sky130_fd_sc_hd__inv_1
X24_inv29 x24_n28 0 0 VPWR VPWR x24_n29 sky130_fd_sc_hd__inv_1
X24_inv30 x24_n29 0 0 VPWR VPWR x24_n30 sky130_fd_sc_hd__inv_1
X24_buf x24_n15 0 0 VPWR VPWR x24_out sky130_fd_sc_hd__buf_1
* --- RO 25 ---
X25_nand EN x25_n30 0 0 VPWR VPWR x25_n0 sky130_fd_sc_hd__nand2_1
X25_inv1 x25_n0 0 0 VPWR VPWR x25_n1 sky130_fd_sc_hd__inv_1
X25_inv2 x25_n1 0 0 VPWR VPWR x25_n2 sky130_fd_sc_hd__inv_1
X25_inv3 x25_n2 0 0 VPWR VPWR x25_n3 sky130_fd_sc_hd__inv_1
X25_inv4 x25_n3 0 0 VPWR VPWR x25_n4 sky130_fd_sc_hd__inv_1
X25_inv5 x25_n4 0 0 VPWR VPWR x25_n5 sky130_fd_sc_hd__inv_1
X25_inv6 x25_n5 0 0 VPWR VPWR x25_n6 sky130_fd_sc_hd__inv_1
X25_inv7 x25_n6 0 0 VPWR VPWR x25_n7 sky130_fd_sc_hd__inv_1
X25_inv8 x25_n7 0 0 VPWR VPWR x25_n8 sky130_fd_sc_hd__inv_1
X25_inv9 x25_n8 0 0 VPWR VPWR x25_n9 sky130_fd_sc_hd__inv_1
X25_inv10 x25_n9 0 0 VPWR VPWR x25_n10 sky130_fd_sc_hd__inv_1
X25_inv11 x25_n10 0 0 VPWR VPWR x25_n11 sky130_fd_sc_hd__inv_1
X25_inv12 x25_n11 0 0 VPWR VPWR x25_n12 sky130_fd_sc_hd__inv_1
X25_inv13 x25_n12 0 0 VPWR VPWR x25_n13 sky130_fd_sc_hd__inv_1
X25_inv14 x25_n13 0 0 VPWR VPWR x25_n14 sky130_fd_sc_hd__inv_1
X25_inv15 x25_n14 0 0 VPWR VPWR x25_n15 sky130_fd_sc_hd__inv_1
X25_inv16 x25_n15 0 0 VPWR VPWR x25_n16 sky130_fd_sc_hd__inv_1
X25_inv17 x25_n16 0 0 VPWR VPWR x25_n17 sky130_fd_sc_hd__inv_1
X25_inv18 x25_n17 0 0 VPWR VPWR x25_n18 sky130_fd_sc_hd__inv_1
X25_inv19 x25_n18 0 0 VPWR VPWR x25_n19 sky130_fd_sc_hd__inv_1
X25_inv20 x25_n19 0 0 VPWR VPWR x25_n20 sky130_fd_sc_hd__inv_1
X25_inv21 x25_n20 0 0 VPWR VPWR x25_n21 sky130_fd_sc_hd__inv_1
X25_inv22 x25_n21 0 0 VPWR VPWR x25_n22 sky130_fd_sc_hd__inv_1
X25_inv23 x25_n22 0 0 VPWR VPWR x25_n23 sky130_fd_sc_hd__inv_1
X25_inv24 x25_n23 0 0 VPWR VPWR x25_n24 sky130_fd_sc_hd__inv_1
X25_inv25 x25_n24 0 0 VPWR VPWR x25_n25 sky130_fd_sc_hd__inv_1
X25_inv26 x25_n25 0 0 VPWR VPWR x25_n26 sky130_fd_sc_hd__inv_1
X25_inv27 x25_n26 0 0 VPWR VPWR x25_n27 sky130_fd_sc_hd__inv_1
X25_inv28 x25_n27 0 0 VPWR VPWR x25_n28 sky130_fd_sc_hd__inv_1
X25_inv29 x25_n28 0 0 VPWR VPWR x25_n29 sky130_fd_sc_hd__inv_1
X25_inv30 x25_n29 0 0 VPWR VPWR x25_n30 sky130_fd_sc_hd__inv_1
X25_buf x25_n15 0 0 VPWR VPWR x25_out sky130_fd_sc_hd__buf_1
* --- RO 26 ---
X26_nand EN x26_n30 0 0 VPWR VPWR x26_n0 sky130_fd_sc_hd__nand2_1
X26_inv1 x26_n0 0 0 VPWR VPWR x26_n1 sky130_fd_sc_hd__inv_1
X26_inv2 x26_n1 0 0 VPWR VPWR x26_n2 sky130_fd_sc_hd__inv_1
X26_inv3 x26_n2 0 0 VPWR VPWR x26_n3 sky130_fd_sc_hd__inv_1
X26_inv4 x26_n3 0 0 VPWR VPWR x26_n4 sky130_fd_sc_hd__inv_1
X26_inv5 x26_n4 0 0 VPWR VPWR x26_n5 sky130_fd_sc_hd__inv_1
X26_inv6 x26_n5 0 0 VPWR VPWR x26_n6 sky130_fd_sc_hd__inv_1
X26_inv7 x26_n6 0 0 VPWR VPWR x26_n7 sky130_fd_sc_hd__inv_1
X26_inv8 x26_n7 0 0 VPWR VPWR x26_n8 sky130_fd_sc_hd__inv_1
X26_inv9 x26_n8 0 0 VPWR VPWR x26_n9 sky130_fd_sc_hd__inv_1
X26_inv10 x26_n9 0 0 VPWR VPWR x26_n10 sky130_fd_sc_hd__inv_1
X26_inv11 x26_n10 0 0 VPWR VPWR x26_n11 sky130_fd_sc_hd__inv_1
X26_inv12 x26_n11 0 0 VPWR VPWR x26_n12 sky130_fd_sc_hd__inv_1
X26_inv13 x26_n12 0 0 VPWR VPWR x26_n13 sky130_fd_sc_hd__inv_1
X26_inv14 x26_n13 0 0 VPWR VPWR x26_n14 sky130_fd_sc_hd__inv_1
X26_inv15 x26_n14 0 0 VPWR VPWR x26_n15 sky130_fd_sc_hd__inv_1
X26_inv16 x26_n15 0 0 VPWR VPWR x26_n16 sky130_fd_sc_hd__inv_1
X26_inv17 x26_n16 0 0 VPWR VPWR x26_n17 sky130_fd_sc_hd__inv_1
X26_inv18 x26_n17 0 0 VPWR VPWR x26_n18 sky130_fd_sc_hd__inv_1
X26_inv19 x26_n18 0 0 VPWR VPWR x26_n19 sky130_fd_sc_hd__inv_1
X26_inv20 x26_n19 0 0 VPWR VPWR x26_n20 sky130_fd_sc_hd__inv_1
X26_inv21 x26_n20 0 0 VPWR VPWR x26_n21 sky130_fd_sc_hd__inv_1
X26_inv22 x26_n21 0 0 VPWR VPWR x26_n22 sky130_fd_sc_hd__inv_1
X26_inv23 x26_n22 0 0 VPWR VPWR x26_n23 sky130_fd_sc_hd__inv_1
X26_inv24 x26_n23 0 0 VPWR VPWR x26_n24 sky130_fd_sc_hd__inv_1
X26_inv25 x26_n24 0 0 VPWR VPWR x26_n25 sky130_fd_sc_hd__inv_1
X26_inv26 x26_n25 0 0 VPWR VPWR x26_n26 sky130_fd_sc_hd__inv_1
X26_inv27 x26_n26 0 0 VPWR VPWR x26_n27 sky130_fd_sc_hd__inv_1
X26_inv28 x26_n27 0 0 VPWR VPWR x26_n28 sky130_fd_sc_hd__inv_1
X26_inv29 x26_n28 0 0 VPWR VPWR x26_n29 sky130_fd_sc_hd__inv_1
X26_inv30 x26_n29 0 0 VPWR VPWR x26_n30 sky130_fd_sc_hd__inv_1
X26_buf x26_n15 0 0 VPWR VPWR x26_out sky130_fd_sc_hd__buf_1
* --- RO 27 ---
X27_nand EN x27_n30 0 0 VPWR VPWR x27_n0 sky130_fd_sc_hd__nand2_1
X27_inv1 x27_n0 0 0 VPWR VPWR x27_n1 sky130_fd_sc_hd__inv_1
X27_inv2 x27_n1 0 0 VPWR VPWR x27_n2 sky130_fd_sc_hd__inv_1
X27_inv3 x27_n2 0 0 VPWR VPWR x27_n3 sky130_fd_sc_hd__inv_1
X27_inv4 x27_n3 0 0 VPWR VPWR x27_n4 sky130_fd_sc_hd__inv_1
X27_inv5 x27_n4 0 0 VPWR VPWR x27_n5 sky130_fd_sc_hd__inv_1
X27_inv6 x27_n5 0 0 VPWR VPWR x27_n6 sky130_fd_sc_hd__inv_1
X27_inv7 x27_n6 0 0 VPWR VPWR x27_n7 sky130_fd_sc_hd__inv_1
X27_inv8 x27_n7 0 0 VPWR VPWR x27_n8 sky130_fd_sc_hd__inv_1
X27_inv9 x27_n8 0 0 VPWR VPWR x27_n9 sky130_fd_sc_hd__inv_1
X27_inv10 x27_n9 0 0 VPWR VPWR x27_n10 sky130_fd_sc_hd__inv_1
X27_inv11 x27_n10 0 0 VPWR VPWR x27_n11 sky130_fd_sc_hd__inv_1
X27_inv12 x27_n11 0 0 VPWR VPWR x27_n12 sky130_fd_sc_hd__inv_1
X27_inv13 x27_n12 0 0 VPWR VPWR x27_n13 sky130_fd_sc_hd__inv_1
X27_inv14 x27_n13 0 0 VPWR VPWR x27_n14 sky130_fd_sc_hd__inv_1
X27_inv15 x27_n14 0 0 VPWR VPWR x27_n15 sky130_fd_sc_hd__inv_1
X27_inv16 x27_n15 0 0 VPWR VPWR x27_n16 sky130_fd_sc_hd__inv_1
X27_inv17 x27_n16 0 0 VPWR VPWR x27_n17 sky130_fd_sc_hd__inv_1
X27_inv18 x27_n17 0 0 VPWR VPWR x27_n18 sky130_fd_sc_hd__inv_1
X27_inv19 x27_n18 0 0 VPWR VPWR x27_n19 sky130_fd_sc_hd__inv_1
X27_inv20 x27_n19 0 0 VPWR VPWR x27_n20 sky130_fd_sc_hd__inv_1
X27_inv21 x27_n20 0 0 VPWR VPWR x27_n21 sky130_fd_sc_hd__inv_1
X27_inv22 x27_n21 0 0 VPWR VPWR x27_n22 sky130_fd_sc_hd__inv_1
X27_inv23 x27_n22 0 0 VPWR VPWR x27_n23 sky130_fd_sc_hd__inv_1
X27_inv24 x27_n23 0 0 VPWR VPWR x27_n24 sky130_fd_sc_hd__inv_1
X27_inv25 x27_n24 0 0 VPWR VPWR x27_n25 sky130_fd_sc_hd__inv_1
X27_inv26 x27_n25 0 0 VPWR VPWR x27_n26 sky130_fd_sc_hd__inv_1
X27_inv27 x27_n26 0 0 VPWR VPWR x27_n27 sky130_fd_sc_hd__inv_1
X27_inv28 x27_n27 0 0 VPWR VPWR x27_n28 sky130_fd_sc_hd__inv_1
X27_inv29 x27_n28 0 0 VPWR VPWR x27_n29 sky130_fd_sc_hd__inv_1
X27_inv30 x27_n29 0 0 VPWR VPWR x27_n30 sky130_fd_sc_hd__inv_1
X27_buf x27_n15 0 0 VPWR VPWR x27_out sky130_fd_sc_hd__buf_1
* --- RO 28 ---
X28_nand EN x28_n30 0 0 VPWR VPWR x28_n0 sky130_fd_sc_hd__nand2_1
X28_inv1 x28_n0 0 0 VPWR VPWR x28_n1 sky130_fd_sc_hd__inv_1
X28_inv2 x28_n1 0 0 VPWR VPWR x28_n2 sky130_fd_sc_hd__inv_1
X28_inv3 x28_n2 0 0 VPWR VPWR x28_n3 sky130_fd_sc_hd__inv_1
X28_inv4 x28_n3 0 0 VPWR VPWR x28_n4 sky130_fd_sc_hd__inv_1
X28_inv5 x28_n4 0 0 VPWR VPWR x28_n5 sky130_fd_sc_hd__inv_1
X28_inv6 x28_n5 0 0 VPWR VPWR x28_n6 sky130_fd_sc_hd__inv_1
X28_inv7 x28_n6 0 0 VPWR VPWR x28_n7 sky130_fd_sc_hd__inv_1
X28_inv8 x28_n7 0 0 VPWR VPWR x28_n8 sky130_fd_sc_hd__inv_1
X28_inv9 x28_n8 0 0 VPWR VPWR x28_n9 sky130_fd_sc_hd__inv_1
X28_inv10 x28_n9 0 0 VPWR VPWR x28_n10 sky130_fd_sc_hd__inv_1
X28_inv11 x28_n10 0 0 VPWR VPWR x28_n11 sky130_fd_sc_hd__inv_1
X28_inv12 x28_n11 0 0 VPWR VPWR x28_n12 sky130_fd_sc_hd__inv_1
X28_inv13 x28_n12 0 0 VPWR VPWR x28_n13 sky130_fd_sc_hd__inv_1
X28_inv14 x28_n13 0 0 VPWR VPWR x28_n14 sky130_fd_sc_hd__inv_1
X28_inv15 x28_n14 0 0 VPWR VPWR x28_n15 sky130_fd_sc_hd__inv_1
X28_inv16 x28_n15 0 0 VPWR VPWR x28_n16 sky130_fd_sc_hd__inv_1
X28_inv17 x28_n16 0 0 VPWR VPWR x28_n17 sky130_fd_sc_hd__inv_1
X28_inv18 x28_n17 0 0 VPWR VPWR x28_n18 sky130_fd_sc_hd__inv_1
X28_inv19 x28_n18 0 0 VPWR VPWR x28_n19 sky130_fd_sc_hd__inv_1
X28_inv20 x28_n19 0 0 VPWR VPWR x28_n20 sky130_fd_sc_hd__inv_1
X28_inv21 x28_n20 0 0 VPWR VPWR x28_n21 sky130_fd_sc_hd__inv_1
X28_inv22 x28_n21 0 0 VPWR VPWR x28_n22 sky130_fd_sc_hd__inv_1
X28_inv23 x28_n22 0 0 VPWR VPWR x28_n23 sky130_fd_sc_hd__inv_1
X28_inv24 x28_n23 0 0 VPWR VPWR x28_n24 sky130_fd_sc_hd__inv_1
X28_inv25 x28_n24 0 0 VPWR VPWR x28_n25 sky130_fd_sc_hd__inv_1
X28_inv26 x28_n25 0 0 VPWR VPWR x28_n26 sky130_fd_sc_hd__inv_1
X28_inv27 x28_n26 0 0 VPWR VPWR x28_n27 sky130_fd_sc_hd__inv_1
X28_inv28 x28_n27 0 0 VPWR VPWR x28_n28 sky130_fd_sc_hd__inv_1
X28_inv29 x28_n28 0 0 VPWR VPWR x28_n29 sky130_fd_sc_hd__inv_1
X28_inv30 x28_n29 0 0 VPWR VPWR x28_n30 sky130_fd_sc_hd__inv_1
X28_buf x28_n15 0 0 VPWR VPWR x28_out sky130_fd_sc_hd__buf_1
* --- RO 29 ---
X29_nand EN x29_n30 0 0 VPWR VPWR x29_n0 sky130_fd_sc_hd__nand2_1
X29_inv1 x29_n0 0 0 VPWR VPWR x29_n1 sky130_fd_sc_hd__inv_1
X29_inv2 x29_n1 0 0 VPWR VPWR x29_n2 sky130_fd_sc_hd__inv_1
X29_inv3 x29_n2 0 0 VPWR VPWR x29_n3 sky130_fd_sc_hd__inv_1
X29_inv4 x29_n3 0 0 VPWR VPWR x29_n4 sky130_fd_sc_hd__inv_1
X29_inv5 x29_n4 0 0 VPWR VPWR x29_n5 sky130_fd_sc_hd__inv_1
X29_inv6 x29_n5 0 0 VPWR VPWR x29_n6 sky130_fd_sc_hd__inv_1
X29_inv7 x29_n6 0 0 VPWR VPWR x29_n7 sky130_fd_sc_hd__inv_1
X29_inv8 x29_n7 0 0 VPWR VPWR x29_n8 sky130_fd_sc_hd__inv_1
X29_inv9 x29_n8 0 0 VPWR VPWR x29_n9 sky130_fd_sc_hd__inv_1
X29_inv10 x29_n9 0 0 VPWR VPWR x29_n10 sky130_fd_sc_hd__inv_1
X29_inv11 x29_n10 0 0 VPWR VPWR x29_n11 sky130_fd_sc_hd__inv_1
X29_inv12 x29_n11 0 0 VPWR VPWR x29_n12 sky130_fd_sc_hd__inv_1
X29_inv13 x29_n12 0 0 VPWR VPWR x29_n13 sky130_fd_sc_hd__inv_1
X29_inv14 x29_n13 0 0 VPWR VPWR x29_n14 sky130_fd_sc_hd__inv_1
X29_inv15 x29_n14 0 0 VPWR VPWR x29_n15 sky130_fd_sc_hd__inv_1
X29_inv16 x29_n15 0 0 VPWR VPWR x29_n16 sky130_fd_sc_hd__inv_1
X29_inv17 x29_n16 0 0 VPWR VPWR x29_n17 sky130_fd_sc_hd__inv_1
X29_inv18 x29_n17 0 0 VPWR VPWR x29_n18 sky130_fd_sc_hd__inv_1
X29_inv19 x29_n18 0 0 VPWR VPWR x29_n19 sky130_fd_sc_hd__inv_1
X29_inv20 x29_n19 0 0 VPWR VPWR x29_n20 sky130_fd_sc_hd__inv_1
X29_inv21 x29_n20 0 0 VPWR VPWR x29_n21 sky130_fd_sc_hd__inv_1
X29_inv22 x29_n21 0 0 VPWR VPWR x29_n22 sky130_fd_sc_hd__inv_1
X29_inv23 x29_n22 0 0 VPWR VPWR x29_n23 sky130_fd_sc_hd__inv_1
X29_inv24 x29_n23 0 0 VPWR VPWR x29_n24 sky130_fd_sc_hd__inv_1
X29_inv25 x29_n24 0 0 VPWR VPWR x29_n25 sky130_fd_sc_hd__inv_1
X29_inv26 x29_n25 0 0 VPWR VPWR x29_n26 sky130_fd_sc_hd__inv_1
X29_inv27 x29_n26 0 0 VPWR VPWR x29_n27 sky130_fd_sc_hd__inv_1
X29_inv28 x29_n27 0 0 VPWR VPWR x29_n28 sky130_fd_sc_hd__inv_1
X29_inv29 x29_n28 0 0 VPWR VPWR x29_n29 sky130_fd_sc_hd__inv_1
X29_inv30 x29_n29 0 0 VPWR VPWR x29_n30 sky130_fd_sc_hd__inv_1
X29_buf x29_n15 0 0 VPWR VPWR x29_out sky130_fd_sc_hd__buf_1
* --- RO 30 ---
X30_nand EN x30_n30 0 0 VPWR VPWR x30_n0 sky130_fd_sc_hd__nand2_1
X30_inv1 x30_n0 0 0 VPWR VPWR x30_n1 sky130_fd_sc_hd__inv_1
X30_inv2 x30_n1 0 0 VPWR VPWR x30_n2 sky130_fd_sc_hd__inv_1
X30_inv3 x30_n2 0 0 VPWR VPWR x30_n3 sky130_fd_sc_hd__inv_1
X30_inv4 x30_n3 0 0 VPWR VPWR x30_n4 sky130_fd_sc_hd__inv_1
X30_inv5 x30_n4 0 0 VPWR VPWR x30_n5 sky130_fd_sc_hd__inv_1
X30_inv6 x30_n5 0 0 VPWR VPWR x30_n6 sky130_fd_sc_hd__inv_1
X30_inv7 x30_n6 0 0 VPWR VPWR x30_n7 sky130_fd_sc_hd__inv_1
X30_inv8 x30_n7 0 0 VPWR VPWR x30_n8 sky130_fd_sc_hd__inv_1
X30_inv9 x30_n8 0 0 VPWR VPWR x30_n9 sky130_fd_sc_hd__inv_1
X30_inv10 x30_n9 0 0 VPWR VPWR x30_n10 sky130_fd_sc_hd__inv_1
X30_inv11 x30_n10 0 0 VPWR VPWR x30_n11 sky130_fd_sc_hd__inv_1
X30_inv12 x30_n11 0 0 VPWR VPWR x30_n12 sky130_fd_sc_hd__inv_1
X30_inv13 x30_n12 0 0 VPWR VPWR x30_n13 sky130_fd_sc_hd__inv_1
X30_inv14 x30_n13 0 0 VPWR VPWR x30_n14 sky130_fd_sc_hd__inv_1
X30_inv15 x30_n14 0 0 VPWR VPWR x30_n15 sky130_fd_sc_hd__inv_1
X30_inv16 x30_n15 0 0 VPWR VPWR x30_n16 sky130_fd_sc_hd__inv_1
X30_inv17 x30_n16 0 0 VPWR VPWR x30_n17 sky130_fd_sc_hd__inv_1
X30_inv18 x30_n17 0 0 VPWR VPWR x30_n18 sky130_fd_sc_hd__inv_1
X30_inv19 x30_n18 0 0 VPWR VPWR x30_n19 sky130_fd_sc_hd__inv_1
X30_inv20 x30_n19 0 0 VPWR VPWR x30_n20 sky130_fd_sc_hd__inv_1
X30_inv21 x30_n20 0 0 VPWR VPWR x30_n21 sky130_fd_sc_hd__inv_1
X30_inv22 x30_n21 0 0 VPWR VPWR x30_n22 sky130_fd_sc_hd__inv_1
X30_inv23 x30_n22 0 0 VPWR VPWR x30_n23 sky130_fd_sc_hd__inv_1
X30_inv24 x30_n23 0 0 VPWR VPWR x30_n24 sky130_fd_sc_hd__inv_1
X30_inv25 x30_n24 0 0 VPWR VPWR x30_n25 sky130_fd_sc_hd__inv_1
X30_inv26 x30_n25 0 0 VPWR VPWR x30_n26 sky130_fd_sc_hd__inv_1
X30_inv27 x30_n26 0 0 VPWR VPWR x30_n27 sky130_fd_sc_hd__inv_1
X30_inv28 x30_n27 0 0 VPWR VPWR x30_n28 sky130_fd_sc_hd__inv_1
X30_inv29 x30_n28 0 0 VPWR VPWR x30_n29 sky130_fd_sc_hd__inv_1
X30_inv30 x30_n29 0 0 VPWR VPWR x30_n30 sky130_fd_sc_hd__inv_1
X30_buf x30_n15 0 0 VPWR VPWR x30_out sky130_fd_sc_hd__buf_1
* --- RO 31 ---
X31_nand EN x31_n30 0 0 VPWR VPWR x31_n0 sky130_fd_sc_hd__nand2_1
X31_inv1 x31_n0 0 0 VPWR VPWR x31_n1 sky130_fd_sc_hd__inv_1
X31_inv2 x31_n1 0 0 VPWR VPWR x31_n2 sky130_fd_sc_hd__inv_1
X31_inv3 x31_n2 0 0 VPWR VPWR x31_n3 sky130_fd_sc_hd__inv_1
X31_inv4 x31_n3 0 0 VPWR VPWR x31_n4 sky130_fd_sc_hd__inv_1
X31_inv5 x31_n4 0 0 VPWR VPWR x31_n5 sky130_fd_sc_hd__inv_1
X31_inv6 x31_n5 0 0 VPWR VPWR x31_n6 sky130_fd_sc_hd__inv_1
X31_inv7 x31_n6 0 0 VPWR VPWR x31_n7 sky130_fd_sc_hd__inv_1
X31_inv8 x31_n7 0 0 VPWR VPWR x31_n8 sky130_fd_sc_hd__inv_1
X31_inv9 x31_n8 0 0 VPWR VPWR x31_n9 sky130_fd_sc_hd__inv_1
X31_inv10 x31_n9 0 0 VPWR VPWR x31_n10 sky130_fd_sc_hd__inv_1
X31_inv11 x31_n10 0 0 VPWR VPWR x31_n11 sky130_fd_sc_hd__inv_1
X31_inv12 x31_n11 0 0 VPWR VPWR x31_n12 sky130_fd_sc_hd__inv_1
X31_inv13 x31_n12 0 0 VPWR VPWR x31_n13 sky130_fd_sc_hd__inv_1
X31_inv14 x31_n13 0 0 VPWR VPWR x31_n14 sky130_fd_sc_hd__inv_1
X31_inv15 x31_n14 0 0 VPWR VPWR x31_n15 sky130_fd_sc_hd__inv_1
X31_inv16 x31_n15 0 0 VPWR VPWR x31_n16 sky130_fd_sc_hd__inv_1
X31_inv17 x31_n16 0 0 VPWR VPWR x31_n17 sky130_fd_sc_hd__inv_1
X31_inv18 x31_n17 0 0 VPWR VPWR x31_n18 sky130_fd_sc_hd__inv_1
X31_inv19 x31_n18 0 0 VPWR VPWR x31_n19 sky130_fd_sc_hd__inv_1
X31_inv20 x31_n19 0 0 VPWR VPWR x31_n20 sky130_fd_sc_hd__inv_1
X31_inv21 x31_n20 0 0 VPWR VPWR x31_n21 sky130_fd_sc_hd__inv_1
X31_inv22 x31_n21 0 0 VPWR VPWR x31_n22 sky130_fd_sc_hd__inv_1
X31_inv23 x31_n22 0 0 VPWR VPWR x31_n23 sky130_fd_sc_hd__inv_1
X31_inv24 x31_n23 0 0 VPWR VPWR x31_n24 sky130_fd_sc_hd__inv_1
X31_inv25 x31_n24 0 0 VPWR VPWR x31_n25 sky130_fd_sc_hd__inv_1
X31_inv26 x31_n25 0 0 VPWR VPWR x31_n26 sky130_fd_sc_hd__inv_1
X31_inv27 x31_n26 0 0 VPWR VPWR x31_n27 sky130_fd_sc_hd__inv_1
X31_inv28 x31_n27 0 0 VPWR VPWR x31_n28 sky130_fd_sc_hd__inv_1
X31_inv29 x31_n28 0 0 VPWR VPWR x31_n29 sky130_fd_sc_hd__inv_1
X31_inv30 x31_n29 0 0 VPWR VPWR x31_n30 sky130_fd_sc_hd__inv_1
X31_buf x31_n15 0 0 VPWR VPWR x31_out sky130_fd_sc_hd__buf_1

.save v(x0_out) v(x1_out) v(x2_out) v(x3_out) v(x4_out) v(x5_out) v(x6_out) v(x7_out) v(x8_out) v(x9_out) v(x10_out) v(x11_out) v(x12_out) v(x13_out) v(x14_out) v(x15_out) v(x16_out) v(x17_out) v(x18_out) v(x19_out) v(x20_out) v(x21_out) v(x22_out) v(x23_out) v(x24_out) v(x25_out) v(x26_out) v(x27_out) v(x28_out) v(x29_out) v(x30_out) v(x31_out)
.tran 5p 80n
.control
run
meas tran tp0 TRIG v(x0_out) VAL=0.9 RISE=5 TARG v(x0_out) VAL=0.9 RISE=25
meas tran tp1 TRIG v(x1_out) VAL=0.9 RISE=5 TARG v(x1_out) VAL=0.9 RISE=25
meas tran tp2 TRIG v(x2_out) VAL=0.9 RISE=5 TARG v(x2_out) VAL=0.9 RISE=25
meas tran tp3 TRIG v(x3_out) VAL=0.9 RISE=5 TARG v(x3_out) VAL=0.9 RISE=25
meas tran tp4 TRIG v(x4_out) VAL=0.9 RISE=5 TARG v(x4_out) VAL=0.9 RISE=25
meas tran tp5 TRIG v(x5_out) VAL=0.9 RISE=5 TARG v(x5_out) VAL=0.9 RISE=25
meas tran tp6 TRIG v(x6_out) VAL=0.9 RISE=5 TARG v(x6_out) VAL=0.9 RISE=25
meas tran tp7 TRIG v(x7_out) VAL=0.9 RISE=5 TARG v(x7_out) VAL=0.9 RISE=25
meas tran tp8 TRIG v(x8_out) VAL=0.9 RISE=5 TARG v(x8_out) VAL=0.9 RISE=25
meas tran tp9 TRIG v(x9_out) VAL=0.9 RISE=5 TARG v(x9_out) VAL=0.9 RISE=25
meas tran tp10 TRIG v(x10_out) VAL=0.9 RISE=5 TARG v(x10_out) VAL=0.9 RISE=25
meas tran tp11 TRIG v(x11_out) VAL=0.9 RISE=5 TARG v(x11_out) VAL=0.9 RISE=25
meas tran tp12 TRIG v(x12_out) VAL=0.9 RISE=5 TARG v(x12_out) VAL=0.9 RISE=25
meas tran tp13 TRIG v(x13_out) VAL=0.9 RISE=5 TARG v(x13_out) VAL=0.9 RISE=25
meas tran tp14 TRIG v(x14_out) VAL=0.9 RISE=5 TARG v(x14_out) VAL=0.9 RISE=25
meas tran tp15 TRIG v(x15_out) VAL=0.9 RISE=5 TARG v(x15_out) VAL=0.9 RISE=25
meas tran tp16 TRIG v(x16_out) VAL=0.9 RISE=5 TARG v(x16_out) VAL=0.9 RISE=25
meas tran tp17 TRIG v(x17_out) VAL=0.9 RISE=5 TARG v(x17_out) VAL=0.9 RISE=25
meas tran tp18 TRIG v(x18_out) VAL=0.9 RISE=5 TARG v(x18_out) VAL=0.9 RISE=25
meas tran tp19 TRIG v(x19_out) VAL=0.9 RISE=5 TARG v(x19_out) VAL=0.9 RISE=25
meas tran tp20 TRIG v(x20_out) VAL=0.9 RISE=5 TARG v(x20_out) VAL=0.9 RISE=25
meas tran tp21 TRIG v(x21_out) VAL=0.9 RISE=5 TARG v(x21_out) VAL=0.9 RISE=25
meas tran tp22 TRIG v(x22_out) VAL=0.9 RISE=5 TARG v(x22_out) VAL=0.9 RISE=25
meas tran tp23 TRIG v(x23_out) VAL=0.9 RISE=5 TARG v(x23_out) VAL=0.9 RISE=25
meas tran tp24 TRIG v(x24_out) VAL=0.9 RISE=5 TARG v(x24_out) VAL=0.9 RISE=25
meas tran tp25 TRIG v(x25_out) VAL=0.9 RISE=5 TARG v(x25_out) VAL=0.9 RISE=25
meas tran tp26 TRIG v(x26_out) VAL=0.9 RISE=5 TARG v(x26_out) VAL=0.9 RISE=25
meas tran tp27 TRIG v(x27_out) VAL=0.9 RISE=5 TARG v(x27_out) VAL=0.9 RISE=25
meas tran tp28 TRIG v(x28_out) VAL=0.9 RISE=5 TARG v(x28_out) VAL=0.9 RISE=25
meas tran tp29 TRIG v(x29_out) VAL=0.9 RISE=5 TARG v(x29_out) VAL=0.9 RISE=25
meas tran tp30 TRIG v(x30_out) VAL=0.9 RISE=5 TARG v(x30_out) VAL=0.9 RISE=25
meas tran tp31 TRIG v(x31_out) VAL=0.9 RISE=5 TARG v(x31_out) VAL=0.9 RISE=25
let f0 = 20 / tp0
let f1 = 20 / tp1
let f2 = 20 / tp2
let f3 = 20 / tp3
let f4 = 20 / tp4
let f5 = 20 / tp5
let f6 = 20 / tp6
let f7 = 20 / tp7
let f8 = 20 / tp8
let f9 = 20 / tp9
let f10 = 20 / tp10
let f11 = 20 / tp11
let f12 = 20 / tp12
let f13 = 20 / tp13
let f14 = 20 / tp14
let f15 = 20 / tp15
let f16 = 20 / tp16
let f17 = 20 / tp17
let f18 = 20 / tp18
let f19 = 20 / tp19
let f20 = 20 / tp20
let f21 = 20 / tp21
let f22 = 20 / tp22
let f23 = 20 / tp23
let f24 = 20 / tp24
let f25 = 20 / tp25
let f26 = 20 / tp26
let f27 = 20 / tp27
let f28 = 20 / tp28
let f29 = 20 / tp29
let f30 = 20 / tp30
let f31 = 20 / tp31
print f0
print f1
print f2
print f3
print f4
print f5
print f6
print f7
print f8
print f9
print f10
print f11
print f12
print f13
print f14
print f15
print f16
print f17
print f18
print f19
print f20
print f21
print f22
print f23
print f24
print f25
print f26
print f27
print f28
print f29
print f30
print f31
.endc
.end
