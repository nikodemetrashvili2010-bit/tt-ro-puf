* SILICON Arm B matched frequency : hardened ro_macro_hard, nom SPEF
* auto-generated by gen_macro_deck.py -- enable-started, same flow as gono
.lib /home/pc/pdks/sky130A/libs.tech/ngspice/sky130.lib.spice tt
.include /home/pc/pdks/sky130A/libs.ref/sky130_fd_sc_hd/spice/sky130_fd_sc_hd.spice
.param SUPPLY=1.8
Vdd VPWR 0 {SUPPLY}
Ven EN 0 PULSE(0 1.8 2n 50p 50p 1 2)

* --- CONTROL (no parasitics) ---
Xa_dlyin  EN 0 0 VPWR VPWR a_net1 sky130_fd_sc_hd__clkdlybuf4s25_1
Xa_nand   a_net1 a_n30 0 0 VPWR VPWR a_n0 sky130_fd_sc_hd__nand2_1
Xa_inv1 a_n0 0 0 VPWR VPWR a_n1 sky130_fd_sc_hd__inv_1
Xa_inv2 a_n1 0 0 VPWR VPWR a_n2 sky130_fd_sc_hd__inv_1
Xa_inv3 a_n2 0 0 VPWR VPWR a_n3 sky130_fd_sc_hd__inv_1
Xa_inv4 a_n3 0 0 VPWR VPWR a_n4 sky130_fd_sc_hd__inv_1
Xa_inv5 a_n4 0 0 VPWR VPWR a_n5 sky130_fd_sc_hd__inv_1
Xa_inv6 a_n5 0 0 VPWR VPWR a_n6 sky130_fd_sc_hd__inv_1
Xa_inv7 a_n6 0 0 VPWR VPWR a_n7 sky130_fd_sc_hd__inv_1
Xa_inv8 a_n7 0 0 VPWR VPWR a_n8 sky130_fd_sc_hd__inv_1
Xa_inv9 a_n8 0 0 VPWR VPWR a_n9 sky130_fd_sc_hd__inv_1
Xa_inv10 a_n9 0 0 VPWR VPWR a_n10 sky130_fd_sc_hd__inv_1
Xa_inv11 a_n10 0 0 VPWR VPWR a_n11 sky130_fd_sc_hd__inv_1
Xa_inv12 a_n11 0 0 VPWR VPWR a_n12 sky130_fd_sc_hd__inv_1
Xa_inv13 a_n12 0 0 VPWR VPWR a_n13 sky130_fd_sc_hd__inv_1
Xa_inv14 a_n13 0 0 VPWR VPWR a_n14 sky130_fd_sc_hd__inv_1
Xa_inv15 a_n14 0 0 VPWR VPWR a_n15 sky130_fd_sc_hd__inv_1
Xa_inv16 a_n15 0 0 VPWR VPWR a_n16 sky130_fd_sc_hd__inv_1
Xa_inv17 a_n16 0 0 VPWR VPWR a_n17 sky130_fd_sc_hd__inv_1
Xa_inv18 a_n17 0 0 VPWR VPWR a_n18 sky130_fd_sc_hd__inv_1
Xa_inv19 a_n18 0 0 VPWR VPWR a_n19 sky130_fd_sc_hd__inv_1
Xa_inv20 a_n19 0 0 VPWR VPWR a_n20 sky130_fd_sc_hd__inv_1
Xa_inv21 a_n20 0 0 VPWR VPWR a_n21 sky130_fd_sc_hd__inv_1
Xa_inv22 a_n21 0 0 VPWR VPWR a_n22 sky130_fd_sc_hd__inv_1
Xa_inv23 a_n22 0 0 VPWR VPWR a_n23 sky130_fd_sc_hd__inv_1
Xa_inv24 a_n23 0 0 VPWR VPWR a_n24 sky130_fd_sc_hd__inv_1
Xa_inv25 a_n24 0 0 VPWR VPWR a_n25 sky130_fd_sc_hd__inv_1
Xa_inv26 a_n25 0 0 VPWR VPWR a_n26 sky130_fd_sc_hd__inv_1
Xa_inv27 a_n26 0 0 VPWR VPWR a_n27 sky130_fd_sc_hd__inv_1
Xa_inv28 a_n27 0 0 VPWR VPWR a_n28 sky130_fd_sc_hd__inv_1
Xa_inv29 a_n28 0 0 VPWR VPWR a_n29 sky130_fd_sc_hd__inv_1
Xa_inv30 a_n29 0 0 VPWR VPWR a_n30 sky130_fd_sc_hd__inv_1
Xa_buf    a_n15 0 0 VPWR VPWR a_net2 sky130_fd_sc_hd__buf_1
Xa_dlyout a_net2 0 0 VPWR VPWR a_out sky130_fd_sc_hd__clkdlybuf4s25_1
* --- PARASITIC (macro nom SPEF) ---
Xb_dlyin  EN 0 0 VPWR VPWR b_net1 sky130_fd_sc_hd__clkdlybuf4s25_1
Xb_nand   b_net1 b_n30 0 0 VPWR VPWR b_n0 sky130_fd_sc_hd__nand2_1
Xb_inv1 b_n0 0 0 VPWR VPWR b_n1 sky130_fd_sc_hd__inv_1
Xb_inv2 b_n1 0 0 VPWR VPWR b_n2 sky130_fd_sc_hd__inv_1
Xb_inv3 b_n2 0 0 VPWR VPWR b_n3 sky130_fd_sc_hd__inv_1
Xb_inv4 b_n3 0 0 VPWR VPWR b_n4 sky130_fd_sc_hd__inv_1
Xb_inv5 b_n4 0 0 VPWR VPWR b_n5 sky130_fd_sc_hd__inv_1
Xb_inv6 b_n5 0 0 VPWR VPWR b_n6 sky130_fd_sc_hd__inv_1
Xb_inv7 b_n6 0 0 VPWR VPWR b_n7 sky130_fd_sc_hd__inv_1
Xb_inv8 b_n7 0 0 VPWR VPWR b_n8 sky130_fd_sc_hd__inv_1
Xb_inv9 b_n8 0 0 VPWR VPWR b_n9 sky130_fd_sc_hd__inv_1
Xb_inv10 b_n9 0 0 VPWR VPWR b_n10 sky130_fd_sc_hd__inv_1
Xb_inv11 b_n10 0 0 VPWR VPWR b_n11 sky130_fd_sc_hd__inv_1
Xb_inv12 b_n11 0 0 VPWR VPWR b_n12 sky130_fd_sc_hd__inv_1
Xb_inv13 b_n12 0 0 VPWR VPWR b_n13 sky130_fd_sc_hd__inv_1
Xb_inv14 b_n13 0 0 VPWR VPWR b_n14 sky130_fd_sc_hd__inv_1
Xb_inv15 b_n14 0 0 VPWR VPWR b_n15 sky130_fd_sc_hd__inv_1
Xb_inv16 b_n15 0 0 VPWR VPWR b_n16 sky130_fd_sc_hd__inv_1
Xb_inv17 b_n16 0 0 VPWR VPWR b_n17 sky130_fd_sc_hd__inv_1
Xb_inv18 b_n17 0 0 VPWR VPWR b_n18 sky130_fd_sc_hd__inv_1
Xb_inv19 b_n18 0 0 VPWR VPWR b_n19 sky130_fd_sc_hd__inv_1
Xb_inv20 b_n19 0 0 VPWR VPWR b_n20 sky130_fd_sc_hd__inv_1
Xb_inv21 b_n20 0 0 VPWR VPWR b_n21 sky130_fd_sc_hd__inv_1
Xb_inv22 b_n21 0 0 VPWR VPWR b_n22 sky130_fd_sc_hd__inv_1
Xb_inv23 b_n22 0 0 VPWR VPWR b_n23 sky130_fd_sc_hd__inv_1
Xb_inv24 b_n23 0 0 VPWR VPWR b_n24 sky130_fd_sc_hd__inv_1
Xb_inv25 b_n24 0 0 VPWR VPWR b_n25 sky130_fd_sc_hd__inv_1
Xb_inv26 b_n25 0 0 VPWR VPWR b_n26 sky130_fd_sc_hd__inv_1
Xb_inv27 b_n26 0 0 VPWR VPWR b_n27 sky130_fd_sc_hd__inv_1
Xb_inv28 b_n27 0 0 VPWR VPWR b_n28 sky130_fd_sc_hd__inv_1
Xb_inv29 b_n28 0 0 VPWR VPWR b_n29 sky130_fd_sc_hd__inv_1
Xb_inv30 b_n29 0 0 VPWR VPWR b_n30 sky130_fd_sc_hd__inv_1
Xb_buf    b_n15 0 0 VPWR VPWR b_net2 sky130_fd_sc_hd__buf_1
Xb_dlyout b_net2 0 0 VPWR VPWR b_out sky130_fd_sc_hd__clkdlybuf4s25_1
Cb_n0 b_n0 0 3.068490e-16
Cb_n1 b_n1 0 2.255910e-16
Cb_n2 b_n2 0 1.067930e-16
Cb_n3 b_n3 0 6.592350e-16
Cb_n4 b_n4 0 4.933900e-16
Cb_n5 b_n5 0 2.255700e-16
Cb_n6 b_n6 0 5.757220e-16
Cb_n7 b_n7 0 5.002390e-16
Cb_n8 b_n8 0 1.628300e-16
Cb_n9 b_n9 0 3.187680e-16
Cb_n10 b_n10 0 1.067930e-16
Cb_n11 b_n11 0 1.067930e-16
Cb_n12 b_n12 0 1.233470e-16
Cb_n13 b_n13 0 1.067930e-16
Cb_n14 b_n14 0 1.231760e-16
Cb_n15 b_n15 0 5.925330e-16
Cb_n16 b_n16 0 2.188230e-16
Cb_n17 b_n17 0 5.031700e-16
Cb_n18 b_n18 0 7.865940e-16
Cb_n19 b_n19 0 6.291400e-16
Cb_n20 b_n20 0 1.820890e-16
Cb_n21 b_n21 0 4.232880e-16
Cb_n22 b_n22 0 1.178430e-16
Cb_n23 b_n23 0 1.629830e-16
Cb_n24 b_n24 0 8.774660e-16
Cb_n25 b_n25 0 1.574940e-16
Cb_n26 b_n26 0 7.696420e-16
Cb_n27 b_n27 0 4.887020e-16
Cb_n28 b_n28 0 2.381970e-16
Cb_n29 b_n29 0 1.081190e-16
Cb_n30 b_n30 0 6.156450e-16
Cb_net1 b_net1 0 5.083940e-16
Cb_net2 b_net2 0 7.365850e-16
Cb_out b_out 0 1.942570e-15
Cb_en EN 0 1.128140e-15

.save v(a_out) v(b_out)
.tran 5p 80n
.control
run
meas tran tp_a TRIG v(a_out) VAL=0.9 RISE=5 TARG v(a_out) VAL=0.9 RISE=25
meas tran tp_b TRIG v(b_out) VAL=0.9 RISE=5 TARG v(b_out) VAL=0.9 RISE=25
let f_a = 20 / tp_a
let f_b = 20 / tp_b
print f_a
print f_b
.endc
.end
