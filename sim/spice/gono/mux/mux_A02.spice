* SILICON Arm B matched frequency : hardened ro_macro_hard, nom SPEF
* auto-generated by gen_macro_deck.py -- enable-started, same flow as gono
.lib /home/pc/pdks/sky130A/libs.tech/ngspice/sky130.lib.spice ff
.temp -40
.include /home/pc/pdks/sky130A/libs.ref/sky130_fd_sc_hd/spice/sky130_fd_sc_hd.spice
.param SUPPLY=1.95
Vdd VPWR 0 {SUPPLY}
Ven EN 0 PULSE(0 1.95 2n 50p 50p 1 2)

* --- CONTROL (no parasitics) ---
* --- PARASITIC (macro nom SPEF) ---
Xb_dlyin  EN 0 0 VPWR VPWR b_net1 sky130_fd_sc_hd__clkdlybuf4s25_1
Xb_nand   b_net1 b_n30 0 0 VPWR VPWR b_n0 sky130_fd_sc_hd__nand2_1
Xb_inv1 b_n0 0 0 VPWR VPWR b_n1 sky130_fd_sc_hd__inv_1
Xb_inv2 b_n1 0 0 VPWR VPWR b_n2 sky130_fd_sc_hd__inv_1
Xb_inv3 b_n2 0 0 VPWR VPWR b_n3 sky130_fd_sc_hd__inv_1
Xb_inv4 b_n3 0 0 VPWR VPWR b_n4 sky130_fd_sc_hd__inv_1
Xb_inv5 b_n4 0 0 VPWR VPWR b_n5 sky130_fd_sc_hd__inv_1
Xb_inv6 b_n5 0 0 VPWR VPWR b_n6 sky130_fd_sc_hd__inv_1
Xb_inv7 b_n6 0 0 VPWR VPWR b_n7 sky130_fd_sc_hd__inv_1
Xb_inv8 b_n7 0 0 VPWR VPWR b_n8 sky130_fd_sc_hd__inv_1
Xb_inv9 b_n8 0 0 VPWR VPWR b_n9 sky130_fd_sc_hd__inv_1
Xb_inv10 b_n9 0 0 VPWR VPWR b_n10 sky130_fd_sc_hd__inv_1
Xb_inv11 b_n10 0 0 VPWR VPWR b_n11 sky130_fd_sc_hd__inv_1
Xb_inv12 b_n11 0 0 VPWR VPWR b_n12 sky130_fd_sc_hd__inv_1
Xb_inv13 b_n12 0 0 VPWR VPWR b_n13 sky130_fd_sc_hd__inv_1
Xb_inv14 b_n13 0 0 VPWR VPWR b_n14 sky130_fd_sc_hd__inv_1
Xb_inv15 b_n14 0 0 VPWR VPWR b_n15 sky130_fd_sc_hd__inv_1
Xb_inv16 b_n15 0 0 VPWR VPWR b_n16 sky130_fd_sc_hd__inv_1
Xb_inv17 b_n16 0 0 VPWR VPWR b_n17 sky130_fd_sc_hd__inv_1
Xb_inv18 b_n17 0 0 VPWR VPWR b_n18 sky130_fd_sc_hd__inv_1
Xb_inv19 b_n18 0 0 VPWR VPWR b_n19 sky130_fd_sc_hd__inv_1
Xb_inv20 b_n19 0 0 VPWR VPWR b_n20 sky130_fd_sc_hd__inv_1
Xb_inv21 b_n20 0 0 VPWR VPWR b_n21 sky130_fd_sc_hd__inv_1
Xb_inv22 b_n21 0 0 VPWR VPWR b_n22 sky130_fd_sc_hd__inv_1
Xb_inv23 b_n22 0 0 VPWR VPWR b_n23 sky130_fd_sc_hd__inv_1
Xb_inv24 b_n23 0 0 VPWR VPWR b_n24 sky130_fd_sc_hd__inv_1
Xb_inv25 b_n24 0 0 VPWR VPWR b_n25 sky130_fd_sc_hd__inv_1
Xb_inv26 b_n25 0 0 VPWR VPWR b_n26 sky130_fd_sc_hd__inv_1
Xb_inv27 b_n26 0 0 VPWR VPWR b_n27 sky130_fd_sc_hd__inv_1
Xb_inv28 b_n27 0 0 VPWR VPWR b_n28 sky130_fd_sc_hd__inv_1
Xb_inv29 b_n28 0 0 VPWR VPWR b_n29 sky130_fd_sc_hd__inv_1
Xb_inv30 b_n29 0 0 VPWR VPWR b_n30 sky130_fd_sc_hd__inv_1
Xb_buf    b_n15 0 0 VPWR VPWR b_net2 sky130_fd_sc_hd__buf_1
Xb_dlyout b_net2 0 0 VPWR VPWR b_out sky130_fd_sc_hd__clkdlybuf4s25_1
Cb_n0 b_n0 0 3.068490e-16
Cb_n1 b_n1 0 2.255910e-16
Cb_n2 b_n2 0 1.067930e-16
Cb_n3 b_n3 0 6.592350e-16
Cb_n4 b_n4 0 4.933900e-16
Cb_n5 b_n5 0 2.255700e-16
Cb_n6 b_n6 0 5.757220e-16
Cb_n7 b_n7 0 5.002390e-16
Cb_n8 b_n8 0 1.628300e-16
Cb_n9 b_n9 0 3.187680e-16
Cb_n10 b_n10 0 1.067930e-16
Cb_n11 b_n11 0 1.067930e-16
Cb_n12 b_n12 0 1.233470e-16
Cb_n13 b_n13 0 1.067930e-16
Cb_n14 b_n14 0 1.231760e-16
Cb_n15 b_n15 0 5.925330e-16
Cb_n16 b_n16 0 2.188230e-16
Cb_n17 b_n17 0 5.031700e-16
Cb_n18 b_n18 0 7.865940e-16
Cb_n19 b_n19 0 6.291400e-16
Cb_n20 b_n20 0 1.820890e-16
Cb_n21 b_n21 0 4.232880e-16
Cb_n22 b_n22 0 1.178430e-16
Cb_n23 b_n23 0 1.629830e-16
Cb_n24 b_n24 0 8.774660e-16
Cb_n25 b_n25 0 1.574940e-16
Cb_n26 b_n26 0 7.696420e-16
Cb_n27 b_n27 0 4.887020e-16
Cb_n28 b_n28 0 2.381970e-16
Cb_n29 b_n29 0 1.081190e-16
Cb_n30 b_n30 0 6.156450e-16
Cb_net1 b_net1 0 5.083940e-16
Cb_net2 b_net2 0 7.365850e-16
Cb_out b_out 0 1.942570e-15
Cb_en EN 0 1.128140e-15

* --- selector path for oscillator A02, 4 cells, open path ---
* chain: a22o_2.B2 a221o_2.C1 a221o_2.B1 o21a_2.A2
* the extracted ring tap b_out stands in for this oscillator
Vone ONE 0 1.95
Xsel0 0 0 ONE b_out 0 0 VPWR VPWR _170_ sky130_fd_sc_hd__a22o_2
Csel0 _170_ 0 4.264210e-15
Xsel1 0 0 0 0 _170_ 0 0 VPWR VPWR _171_ sky130_fd_sc_hd__a221o_2
Csel1 _171_ 0 6.190930e-15
Xsel2 0 0 _171_ ONE 0 0 0 VPWR VPWR _173_ sky130_fd_sc_hd__a221o_2
Csel2 _173_ 0 1.339260e-15
Xsel3 0 _173_ ONE 0 0 VPWR VPWR u_puf_u_core_sel_ro sky130_fd_sc_hd__o21a_2
Csel3 u_puf_u_core_sel_ro 0 2.984310e-15

* --- first ripple stage, a real dfrtp_2 wired as a toggle flop ---
Vrstn RSTN 0 PULSE(0 1.95 1n 50p 50p 500n 1000n)
Xff_inv q 0 0 VPWR VPWR qbar sky130_fd_sc_hd__inv_1
Xff u_puf_u_core_sel_ro qbar RSTN 0 0 VPWR VPWR q sky130_fd_sc_hd__dfrtp_2

.save v(b_out) v(u_puf_u_core_sel_ro) v(q)
.tran 1p 42.0n
.control
run
set wr_vecnames
wrdata mux_A02.raw.txt v(b_out) v(u_puf_u_core_sel_ro) v(q)
quit
.endc
.END
