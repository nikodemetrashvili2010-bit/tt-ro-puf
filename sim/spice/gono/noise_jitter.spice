* Operating point and noise floor: slope at threshold, rings 7, 13, 14
* auto-generated by gen_noise_decks.py, ring topology from gen_dualarm_decks.py
.lib "/home/pc/pdks/sky130A/libs.tech/ngspice/sky130.lib.spice" tt
.include "/home/pc/pdks/sky130A/libs.ref/sky130_fd_sc_hd/spice/sky130_fd_sc_hd.spice"
.param SUPPLY=1.8
Vdd VPWR 0 {SUPPLY}
Ven EN 0 PULSE(0 1.8 2n 50p 50p 1 2)

* --- RO 7 ---
X7_nand EN x7_n30 0 0 VPWR VPWR x7_n0 sky130_fd_sc_hd__nand2_1
X7_inv1 x7_n0 0 0 VPWR VPWR x7_n1 sky130_fd_sc_hd__inv_1
X7_inv2 x7_n1 0 0 VPWR VPWR x7_n2 sky130_fd_sc_hd__inv_1
X7_inv3 x7_n2 0 0 VPWR VPWR x7_n3 sky130_fd_sc_hd__inv_1
X7_inv4 x7_n3 0 0 VPWR VPWR x7_n4 sky130_fd_sc_hd__inv_1
X7_inv5 x7_n4 0 0 VPWR VPWR x7_n5 sky130_fd_sc_hd__inv_1
X7_inv6 x7_n5 0 0 VPWR VPWR x7_n6 sky130_fd_sc_hd__inv_1
X7_inv7 x7_n6 0 0 VPWR VPWR x7_n7 sky130_fd_sc_hd__inv_1
X7_inv8 x7_n7 0 0 VPWR VPWR x7_n8 sky130_fd_sc_hd__inv_1
X7_inv9 x7_n8 0 0 VPWR VPWR x7_n9 sky130_fd_sc_hd__inv_1
X7_inv10 x7_n9 0 0 VPWR VPWR x7_n10 sky130_fd_sc_hd__inv_1
X7_inv11 x7_n10 0 0 VPWR VPWR x7_n11 sky130_fd_sc_hd__inv_1
X7_inv12 x7_n11 0 0 VPWR VPWR x7_n12 sky130_fd_sc_hd__inv_1
X7_inv13 x7_n12 0 0 VPWR VPWR x7_n13 sky130_fd_sc_hd__inv_1
X7_inv14 x7_n13 0 0 VPWR VPWR x7_n14 sky130_fd_sc_hd__inv_1
X7_inv15 x7_n14 0 0 VPWR VPWR x7_n15 sky130_fd_sc_hd__inv_1
X7_inv16 x7_n15 0 0 VPWR VPWR x7_n16 sky130_fd_sc_hd__inv_1
X7_inv17 x7_n16 0 0 VPWR VPWR x7_n17 sky130_fd_sc_hd__inv_1
X7_inv18 x7_n17 0 0 VPWR VPWR x7_n18 sky130_fd_sc_hd__inv_1
X7_inv19 x7_n18 0 0 VPWR VPWR x7_n19 sky130_fd_sc_hd__inv_1
X7_inv20 x7_n19 0 0 VPWR VPWR x7_n20 sky130_fd_sc_hd__inv_1
X7_inv21 x7_n20 0 0 VPWR VPWR x7_n21 sky130_fd_sc_hd__inv_1
X7_inv22 x7_n21 0 0 VPWR VPWR x7_n22 sky130_fd_sc_hd__inv_1
X7_inv23 x7_n22 0 0 VPWR VPWR x7_n23 sky130_fd_sc_hd__inv_1
X7_inv24 x7_n23 0 0 VPWR VPWR x7_n24 sky130_fd_sc_hd__inv_1
X7_inv25 x7_n24 0 0 VPWR VPWR x7_n25 sky130_fd_sc_hd__inv_1
X7_inv26 x7_n25 0 0 VPWR VPWR x7_n26 sky130_fd_sc_hd__inv_1
X7_inv27 x7_n26 0 0 VPWR VPWR x7_n27 sky130_fd_sc_hd__inv_1
X7_inv28 x7_n27 0 0 VPWR VPWR x7_n28 sky130_fd_sc_hd__inv_1
X7_inv29 x7_n28 0 0 VPWR VPWR x7_n29 sky130_fd_sc_hd__inv_1
X7_inv30 x7_n29 0 0 VPWR VPWR x7_n30 sky130_fd_sc_hd__inv_1
X7_buf x7_n15 0 0 VPWR VPWR x7_out sky130_fd_sc_hd__buf_1
C7_n0 x7_n0 0 2.438100e-16
C7_n1 x7_n1 0 4.866620e-16
C7_n2 x7_n2 0 3.099440e-16
C7_n3 x7_n3 0 2.433310e-16
C7_n4 x7_n4 0 2.045530e-16
C7_n5 x7_n5 0 1.197900e-16
C7_n6 x7_n6 0 5.339860e-16
C7_n7 x7_n7 0 3.134190e-16
C7_n8 x7_n8 0 5.399160e-16
C7_n9 x7_n9 0 5.893120e-16
C7_n10 x7_n10 0 3.271780e-16
C7_n11 x7_n11 0 3.851110e-16
C7_n12 x7_n12 0 4.241080e-16
C7_n13 x7_n13 0 5.061830e-16
C7_n14 x7_n14 0 2.843180e-16
C7_n15 x7_n15 0 9.149580e-16
C7_n16 x7_n16 0 1.067930e-16
C7_n17 x7_n17 0 1.556730e-16
C7_n18 x7_n18 0 1.067930e-16
C7_n19 x7_n19 0 1.067930e-16
C7_n20 x7_n20 0 1.131280e-16
C7_n21 x7_n21 0 5.584050e-16
C7_n22 x7_n22 0 1.067930e-16
C7_n23 x7_n23 0 1.067930e-16
C7_n24 x7_n24 0 4.225690e-16
C7_n25 x7_n25 0 6.806500e-16
C7_n26 x7_n26 0 2.903440e-16
C7_n27 x7_n27 0 3.115240e-16
C7_n28 x7_n28 0 3.302610e-16
C7_n29 x7_n29 0 4.638450e-16
C7_n30 x7_n30 0 5.744990e-16
C7_out x7_out 0 1.762620e-15
* --- RO 13 ---
X13_nand EN x13_n30 0 0 VPWR VPWR x13_n0 sky130_fd_sc_hd__nand2_1
X13_inv1 x13_n0 0 0 VPWR VPWR x13_n1 sky130_fd_sc_hd__inv_1
X13_inv2 x13_n1 0 0 VPWR VPWR x13_n2 sky130_fd_sc_hd__inv_1
X13_inv3 x13_n2 0 0 VPWR VPWR x13_n3 sky130_fd_sc_hd__inv_1
X13_inv4 x13_n3 0 0 VPWR VPWR x13_n4 sky130_fd_sc_hd__inv_1
X13_inv5 x13_n4 0 0 VPWR VPWR x13_n5 sky130_fd_sc_hd__inv_1
X13_inv6 x13_n5 0 0 VPWR VPWR x13_n6 sky130_fd_sc_hd__inv_1
X13_inv7 x13_n6 0 0 VPWR VPWR x13_n7 sky130_fd_sc_hd__inv_1
X13_inv8 x13_n7 0 0 VPWR VPWR x13_n8 sky130_fd_sc_hd__inv_1
X13_inv9 x13_n8 0 0 VPWR VPWR x13_n9 sky130_fd_sc_hd__inv_1
X13_inv10 x13_n9 0 0 VPWR VPWR x13_n10 sky130_fd_sc_hd__inv_1
X13_inv11 x13_n10 0 0 VPWR VPWR x13_n11 sky130_fd_sc_hd__inv_1
X13_inv12 x13_n11 0 0 VPWR VPWR x13_n12 sky130_fd_sc_hd__inv_1
X13_inv13 x13_n12 0 0 VPWR VPWR x13_n13 sky130_fd_sc_hd__inv_1
X13_inv14 x13_n13 0 0 VPWR VPWR x13_n14 sky130_fd_sc_hd__inv_1
X13_inv15 x13_n14 0 0 VPWR VPWR x13_n15 sky130_fd_sc_hd__inv_1
X13_inv16 x13_n15 0 0 VPWR VPWR x13_n16 sky130_fd_sc_hd__inv_1
X13_inv17 x13_n16 0 0 VPWR VPWR x13_n17 sky130_fd_sc_hd__inv_1
X13_inv18 x13_n17 0 0 VPWR VPWR x13_n18 sky130_fd_sc_hd__inv_1
X13_inv19 x13_n18 0 0 VPWR VPWR x13_n19 sky130_fd_sc_hd__inv_1
X13_inv20 x13_n19 0 0 VPWR VPWR x13_n20 sky130_fd_sc_hd__inv_1
X13_inv21 x13_n20 0 0 VPWR VPWR x13_n21 sky130_fd_sc_hd__inv_1
X13_inv22 x13_n21 0 0 VPWR VPWR x13_n22 sky130_fd_sc_hd__inv_1
X13_inv23 x13_n22 0 0 VPWR VPWR x13_n23 sky130_fd_sc_hd__inv_1
X13_inv24 x13_n23 0 0 VPWR VPWR x13_n24 sky130_fd_sc_hd__inv_1
X13_inv25 x13_n24 0 0 VPWR VPWR x13_n25 sky130_fd_sc_hd__inv_1
X13_inv26 x13_n25 0 0 VPWR VPWR x13_n26 sky130_fd_sc_hd__inv_1
X13_inv27 x13_n26 0 0 VPWR VPWR x13_n27 sky130_fd_sc_hd__inv_1
X13_inv28 x13_n27 0 0 VPWR VPWR x13_n28 sky130_fd_sc_hd__inv_1
X13_inv29 x13_n28 0 0 VPWR VPWR x13_n29 sky130_fd_sc_hd__inv_1
X13_inv30 x13_n29 0 0 VPWR VPWR x13_n30 sky130_fd_sc_hd__inv_1
X13_buf x13_n15 0 0 VPWR VPWR x13_out sky130_fd_sc_hd__buf_1
C13_n0 x13_n0 0 2.180210e-16
C13_n1 x13_n1 0 5.941930e-16
C13_n2 x13_n2 0 3.002170e-16
C13_n3 x13_n3 0 4.210720e-16
C13_n4 x13_n4 0 4.084350e-16
C13_n5 x13_n5 0 4.109750e-16
C13_n6 x13_n6 0 6.216250e-16
C13_n7 x13_n7 0 3.721540e-16
C13_n8 x13_n8 0 4.768440e-16
C13_n9 x13_n9 0 4.771200e-16
C13_n10 x13_n10 0 1.024730e-15
C13_n11 x13_n11 0 3.137880e-16
C13_n12 x13_n12 0 3.713810e-16
C13_n13 x13_n13 0 4.835500e-16
C13_n14 x13_n14 0 2.333970e-16
C13_n15 x13_n15 0 7.104940e-16
C13_n16 x13_n16 0 5.629540e-16
C13_n17 x13_n17 0 1.989430e-16
C13_n18 x13_n18 0 4.459520e-16
C13_n19 x13_n19 0 5.136740e-16
C13_n20 x13_n20 0 1.887390e-16
C13_n21 x13_n21 0 7.970690e-16
C13_n22 x13_n22 0 4.237860e-16
C13_n23 x13_n23 0 2.931360e-16
C13_n24 x13_n24 0 3.751900e-16
C13_n25 x13_n25 0 2.957620e-16
C13_n26 x13_n26 0 4.179460e-16
C13_n27 x13_n27 0 4.961020e-16
C13_n28 x13_n28 0 3.717700e-16
C13_n29 x13_n29 0 4.473580e-16
C13_n30 x13_n30 0 8.974820e-16
C13_out x13_out 0 3.143400e-16
* --- RO 14 ---
X14_nand EN x14_n30 0 0 VPWR VPWR x14_n0 sky130_fd_sc_hd__nand2_1
X14_inv1 x14_n0 0 0 VPWR VPWR x14_n1 sky130_fd_sc_hd__inv_1
X14_inv2 x14_n1 0 0 VPWR VPWR x14_n2 sky130_fd_sc_hd__inv_1
X14_inv3 x14_n2 0 0 VPWR VPWR x14_n3 sky130_fd_sc_hd__inv_1
X14_inv4 x14_n3 0 0 VPWR VPWR x14_n4 sky130_fd_sc_hd__inv_1
X14_inv5 x14_n4 0 0 VPWR VPWR x14_n5 sky130_fd_sc_hd__inv_1
X14_inv6 x14_n5 0 0 VPWR VPWR x14_n6 sky130_fd_sc_hd__inv_1
X14_inv7 x14_n6 0 0 VPWR VPWR x14_n7 sky130_fd_sc_hd__inv_1
X14_inv8 x14_n7 0 0 VPWR VPWR x14_n8 sky130_fd_sc_hd__inv_1
X14_inv9 x14_n8 0 0 VPWR VPWR x14_n9 sky130_fd_sc_hd__inv_1
X14_inv10 x14_n9 0 0 VPWR VPWR x14_n10 sky130_fd_sc_hd__inv_1
X14_inv11 x14_n10 0 0 VPWR VPWR x14_n11 sky130_fd_sc_hd__inv_1
X14_inv12 x14_n11 0 0 VPWR VPWR x14_n12 sky130_fd_sc_hd__inv_1
X14_inv13 x14_n12 0 0 VPWR VPWR x14_n13 sky130_fd_sc_hd__inv_1
X14_inv14 x14_n13 0 0 VPWR VPWR x14_n14 sky130_fd_sc_hd__inv_1
X14_inv15 x14_n14 0 0 VPWR VPWR x14_n15 sky130_fd_sc_hd__inv_1
X14_inv16 x14_n15 0 0 VPWR VPWR x14_n16 sky130_fd_sc_hd__inv_1
X14_inv17 x14_n16 0 0 VPWR VPWR x14_n17 sky130_fd_sc_hd__inv_1
X14_inv18 x14_n17 0 0 VPWR VPWR x14_n18 sky130_fd_sc_hd__inv_1
X14_inv19 x14_n18 0 0 VPWR VPWR x14_n19 sky130_fd_sc_hd__inv_1
X14_inv20 x14_n19 0 0 VPWR VPWR x14_n20 sky130_fd_sc_hd__inv_1
X14_inv21 x14_n20 0 0 VPWR VPWR x14_n21 sky130_fd_sc_hd__inv_1
X14_inv22 x14_n21 0 0 VPWR VPWR x14_n22 sky130_fd_sc_hd__inv_1
X14_inv23 x14_n22 0 0 VPWR VPWR x14_n23 sky130_fd_sc_hd__inv_1
X14_inv24 x14_n23 0 0 VPWR VPWR x14_n24 sky130_fd_sc_hd__inv_1
X14_inv25 x14_n24 0 0 VPWR VPWR x14_n25 sky130_fd_sc_hd__inv_1
X14_inv26 x14_n25 0 0 VPWR VPWR x14_n26 sky130_fd_sc_hd__inv_1
X14_inv27 x14_n26 0 0 VPWR VPWR x14_n27 sky130_fd_sc_hd__inv_1
X14_inv28 x14_n27 0 0 VPWR VPWR x14_n28 sky130_fd_sc_hd__inv_1
X14_inv29 x14_n28 0 0 VPWR VPWR x14_n29 sky130_fd_sc_hd__inv_1
X14_inv30 x14_n29 0 0 VPWR VPWR x14_n30 sky130_fd_sc_hd__inv_1
X14_buf x14_n15 0 0 VPWR VPWR x14_out sky130_fd_sc_hd__buf_1
C14_n0 x14_n0 0 6.625920e-16
C14_n1 x14_n1 0 2.125310e-16
C14_n2 x14_n2 0 3.622510e-16
C14_n3 x14_n3 0 7.311210e-16
C14_n4 x14_n4 0 9.699290e-16
C14_n5 x14_n5 0 5.345560e-16
C14_n6 x14_n6 0 1.838000e-15
C14_n7 x14_n7 0 1.593700e-16
C14_n8 x14_n8 0 1.598080e-16
C14_n9 x14_n9 0 5.877900e-16
C14_n10 x14_n10 0 5.498070e-16
C14_n11 x14_n11 0 5.755880e-16
C14_n12 x14_n12 0 1.085060e-15
C14_n13 x14_n13 0 1.414830e-16
C14_n14 x14_n14 0 8.613920e-16
C14_n15 x14_n15 0 6.473180e-16
C14_n16 x14_n16 0 6.736990e-16
C14_n17 x14_n17 0 3.630720e-16
C14_n18 x14_n18 0 4.108720e-16
C14_n19 x14_n19 0 3.288500e-16
C14_n20 x14_n20 0 4.019030e-16
C14_n21 x14_n21 0 4.931800e-16
C14_n22 x14_n22 0 2.951510e-16
C14_n23 x14_n23 0 3.541250e-16
C14_n24 x14_n24 0 4.890060e-16
C14_n25 x14_n25 0 1.111260e-15
C14_n26 x14_n26 0 3.759770e-16
C14_n27 x14_n27 0 3.387270e-16
C14_n28 x14_n28 0 1.628300e-16
C14_n29 x14_n29 0 6.432870e-16
C14_n30 x14_n30 0 5.206630e-16
C14_out x14_out 0 7.935600e-16

.save v(x7_n0) v(x7_n1) v(x7_n2) v(x7_n3) v(x7_n4) v(x7_n5) v(x7_n6) v(x7_n7) v(x7_n8) v(x7_n9) v(x7_n10) v(x7_n11) v(x7_n12) v(x7_n13) v(x7_n14) v(x7_n15) v(x7_n16) v(x7_n17) v(x7_n18) v(x7_n19) v(x7_n20) v(x7_n21) v(x7_n22) v(x7_n23) v(x7_n24) v(x7_n25) v(x7_n26) v(x7_n27) v(x7_n28) v(x7_n29) v(x7_n30) v(x7_out) v(x13_n0) v(x13_n1) v(x13_n2) v(x13_n3) v(x13_n4) v(x13_n5) v(x13_n6) v(x13_n7) v(x13_n8) v(x13_n9) v(x13_n10) v(x13_n11) v(x13_n12) v(x13_n13) v(x13_n14) v(x13_n15) v(x13_n16) v(x13_n17) v(x13_n18) v(x13_n19) v(x13_n20) v(x13_n21) v(x13_n22) v(x13_n23) v(x13_n24) v(x13_n25) v(x13_n26) v(x13_n27) v(x13_n28) v(x13_n29) v(x13_n30) v(x13_out) v(x14_n0) v(x14_n1) v(x14_n2) v(x14_n3) v(x14_n4) v(x14_n5) v(x14_n6) v(x14_n7) v(x14_n8) v(x14_n9) v(x14_n10) v(x14_n11) v(x14_n12) v(x14_n13) v(x14_n14) v(x14_n15) v(x14_n16) v(x14_n17) v(x14_n18) v(x14_n19) v(x14_n20) v(x14_n21) v(x14_n22) v(x14_n23) v(x14_n24) v(x14_n25) v(x14_n26) v(x14_n27) v(x14_n28) v(x14_n29) v(x14_n30) v(x14_out)
.tran 0.5p 40n
.control
run
meas tran tr_7_0 TRIG v(x7_n0) VAL=0.81 RISE=10 TARG v(x7_n0) VAL=0.99 RISE=10
meas tran tf_7_0 TRIG v(x7_n0) VAL=0.99 FALL=10 TARG v(x7_n0) VAL=0.81 FALL=10
meas tran tr_7_1 TRIG v(x7_n1) VAL=0.81 RISE=10 TARG v(x7_n1) VAL=0.99 RISE=10
meas tran tf_7_1 TRIG v(x7_n1) VAL=0.99 FALL=10 TARG v(x7_n1) VAL=0.81 FALL=10
meas tran tr_7_2 TRIG v(x7_n2) VAL=0.81 RISE=10 TARG v(x7_n2) VAL=0.99 RISE=10
meas tran tf_7_2 TRIG v(x7_n2) VAL=0.99 FALL=10 TARG v(x7_n2) VAL=0.81 FALL=10
meas tran tr_7_3 TRIG v(x7_n3) VAL=0.81 RISE=10 TARG v(x7_n3) VAL=0.99 RISE=10
meas tran tf_7_3 TRIG v(x7_n3) VAL=0.99 FALL=10 TARG v(x7_n3) VAL=0.81 FALL=10
meas tran tr_7_4 TRIG v(x7_n4) VAL=0.81 RISE=10 TARG v(x7_n4) VAL=0.99 RISE=10
meas tran tf_7_4 TRIG v(x7_n4) VAL=0.99 FALL=10 TARG v(x7_n4) VAL=0.81 FALL=10
meas tran tr_7_5 TRIG v(x7_n5) VAL=0.81 RISE=10 TARG v(x7_n5) VAL=0.99 RISE=10
meas tran tf_7_5 TRIG v(x7_n5) VAL=0.99 FALL=10 TARG v(x7_n5) VAL=0.81 FALL=10
meas tran tr_7_6 TRIG v(x7_n6) VAL=0.81 RISE=10 TARG v(x7_n6) VAL=0.99 RISE=10
meas tran tf_7_6 TRIG v(x7_n6) VAL=0.99 FALL=10 TARG v(x7_n6) VAL=0.81 FALL=10
meas tran tr_7_7 TRIG v(x7_n7) VAL=0.81 RISE=10 TARG v(x7_n7) VAL=0.99 RISE=10
meas tran tf_7_7 TRIG v(x7_n7) VAL=0.99 FALL=10 TARG v(x7_n7) VAL=0.81 FALL=10
meas tran tr_7_8 TRIG v(x7_n8) VAL=0.81 RISE=10 TARG v(x7_n8) VAL=0.99 RISE=10
meas tran tf_7_8 TRIG v(x7_n8) VAL=0.99 FALL=10 TARG v(x7_n8) VAL=0.81 FALL=10
meas tran tr_7_9 TRIG v(x7_n9) VAL=0.81 RISE=10 TARG v(x7_n9) VAL=0.99 RISE=10
meas tran tf_7_9 TRIG v(x7_n9) VAL=0.99 FALL=10 TARG v(x7_n9) VAL=0.81 FALL=10
meas tran tr_7_10 TRIG v(x7_n10) VAL=0.81 RISE=10 TARG v(x7_n10) VAL=0.99 RISE=10
meas tran tf_7_10 TRIG v(x7_n10) VAL=0.99 FALL=10 TARG v(x7_n10) VAL=0.81 FALL=10
meas tran tr_7_11 TRIG v(x7_n11) VAL=0.81 RISE=10 TARG v(x7_n11) VAL=0.99 RISE=10
meas tran tf_7_11 TRIG v(x7_n11) VAL=0.99 FALL=10 TARG v(x7_n11) VAL=0.81 FALL=10
meas tran tr_7_12 TRIG v(x7_n12) VAL=0.81 RISE=10 TARG v(x7_n12) VAL=0.99 RISE=10
meas tran tf_7_12 TRIG v(x7_n12) VAL=0.99 FALL=10 TARG v(x7_n12) VAL=0.81 FALL=10
meas tran tr_7_13 TRIG v(x7_n13) VAL=0.81 RISE=10 TARG v(x7_n13) VAL=0.99 RISE=10
meas tran tf_7_13 TRIG v(x7_n13) VAL=0.99 FALL=10 TARG v(x7_n13) VAL=0.81 FALL=10
meas tran tr_7_14 TRIG v(x7_n14) VAL=0.81 RISE=10 TARG v(x7_n14) VAL=0.99 RISE=10
meas tran tf_7_14 TRIG v(x7_n14) VAL=0.99 FALL=10 TARG v(x7_n14) VAL=0.81 FALL=10
meas tran tr_7_15 TRIG v(x7_n15) VAL=0.81 RISE=10 TARG v(x7_n15) VAL=0.99 RISE=10
meas tran tf_7_15 TRIG v(x7_n15) VAL=0.99 FALL=10 TARG v(x7_n15) VAL=0.81 FALL=10
meas tran tr_7_16 TRIG v(x7_n16) VAL=0.81 RISE=10 TARG v(x7_n16) VAL=0.99 RISE=10
meas tran tf_7_16 TRIG v(x7_n16) VAL=0.99 FALL=10 TARG v(x7_n16) VAL=0.81 FALL=10
meas tran tr_7_17 TRIG v(x7_n17) VAL=0.81 RISE=10 TARG v(x7_n17) VAL=0.99 RISE=10
meas tran tf_7_17 TRIG v(x7_n17) VAL=0.99 FALL=10 TARG v(x7_n17) VAL=0.81 FALL=10
meas tran tr_7_18 TRIG v(x7_n18) VAL=0.81 RISE=10 TARG v(x7_n18) VAL=0.99 RISE=10
meas tran tf_7_18 TRIG v(x7_n18) VAL=0.99 FALL=10 TARG v(x7_n18) VAL=0.81 FALL=10
meas tran tr_7_19 TRIG v(x7_n19) VAL=0.81 RISE=10 TARG v(x7_n19) VAL=0.99 RISE=10
meas tran tf_7_19 TRIG v(x7_n19) VAL=0.99 FALL=10 TARG v(x7_n19) VAL=0.81 FALL=10
meas tran tr_7_20 TRIG v(x7_n20) VAL=0.81 RISE=10 TARG v(x7_n20) VAL=0.99 RISE=10
meas tran tf_7_20 TRIG v(x7_n20) VAL=0.99 FALL=10 TARG v(x7_n20) VAL=0.81 FALL=10
meas tran tr_7_21 TRIG v(x7_n21) VAL=0.81 RISE=10 TARG v(x7_n21) VAL=0.99 RISE=10
meas tran tf_7_21 TRIG v(x7_n21) VAL=0.99 FALL=10 TARG v(x7_n21) VAL=0.81 FALL=10
meas tran tr_7_22 TRIG v(x7_n22) VAL=0.81 RISE=10 TARG v(x7_n22) VAL=0.99 RISE=10
meas tran tf_7_22 TRIG v(x7_n22) VAL=0.99 FALL=10 TARG v(x7_n22) VAL=0.81 FALL=10
meas tran tr_7_23 TRIG v(x7_n23) VAL=0.81 RISE=10 TARG v(x7_n23) VAL=0.99 RISE=10
meas tran tf_7_23 TRIG v(x7_n23) VAL=0.99 FALL=10 TARG v(x7_n23) VAL=0.81 FALL=10
meas tran tr_7_24 TRIG v(x7_n24) VAL=0.81 RISE=10 TARG v(x7_n24) VAL=0.99 RISE=10
meas tran tf_7_24 TRIG v(x7_n24) VAL=0.99 FALL=10 TARG v(x7_n24) VAL=0.81 FALL=10
meas tran tr_7_25 TRIG v(x7_n25) VAL=0.81 RISE=10 TARG v(x7_n25) VAL=0.99 RISE=10
meas tran tf_7_25 TRIG v(x7_n25) VAL=0.99 FALL=10 TARG v(x7_n25) VAL=0.81 FALL=10
meas tran tr_7_26 TRIG v(x7_n26) VAL=0.81 RISE=10 TARG v(x7_n26) VAL=0.99 RISE=10
meas tran tf_7_26 TRIG v(x7_n26) VAL=0.99 FALL=10 TARG v(x7_n26) VAL=0.81 FALL=10
meas tran tr_7_27 TRIG v(x7_n27) VAL=0.81 RISE=10 TARG v(x7_n27) VAL=0.99 RISE=10
meas tran tf_7_27 TRIG v(x7_n27) VAL=0.99 FALL=10 TARG v(x7_n27) VAL=0.81 FALL=10
meas tran tr_7_28 TRIG v(x7_n28) VAL=0.81 RISE=10 TARG v(x7_n28) VAL=0.99 RISE=10
meas tran tf_7_28 TRIG v(x7_n28) VAL=0.99 FALL=10 TARG v(x7_n28) VAL=0.81 FALL=10
meas tran tr_7_29 TRIG v(x7_n29) VAL=0.81 RISE=10 TARG v(x7_n29) VAL=0.99 RISE=10
meas tran tf_7_29 TRIG v(x7_n29) VAL=0.99 FALL=10 TARG v(x7_n29) VAL=0.81 FALL=10
meas tran tr_7_30 TRIG v(x7_n30) VAL=0.81 RISE=10 TARG v(x7_n30) VAL=0.99 RISE=10
meas tran tf_7_30 TRIG v(x7_n30) VAL=0.99 FALL=10 TARG v(x7_n30) VAL=0.81 FALL=10
meas tran tr_13_0 TRIG v(x13_n0) VAL=0.81 RISE=10 TARG v(x13_n0) VAL=0.99 RISE=10
meas tran tf_13_0 TRIG v(x13_n0) VAL=0.99 FALL=10 TARG v(x13_n0) VAL=0.81 FALL=10
meas tran tr_13_1 TRIG v(x13_n1) VAL=0.81 RISE=10 TARG v(x13_n1) VAL=0.99 RISE=10
meas tran tf_13_1 TRIG v(x13_n1) VAL=0.99 FALL=10 TARG v(x13_n1) VAL=0.81 FALL=10
meas tran tr_13_2 TRIG v(x13_n2) VAL=0.81 RISE=10 TARG v(x13_n2) VAL=0.99 RISE=10
meas tran tf_13_2 TRIG v(x13_n2) VAL=0.99 FALL=10 TARG v(x13_n2) VAL=0.81 FALL=10
meas tran tr_13_3 TRIG v(x13_n3) VAL=0.81 RISE=10 TARG v(x13_n3) VAL=0.99 RISE=10
meas tran tf_13_3 TRIG v(x13_n3) VAL=0.99 FALL=10 TARG v(x13_n3) VAL=0.81 FALL=10
meas tran tr_13_4 TRIG v(x13_n4) VAL=0.81 RISE=10 TARG v(x13_n4) VAL=0.99 RISE=10
meas tran tf_13_4 TRIG v(x13_n4) VAL=0.99 FALL=10 TARG v(x13_n4) VAL=0.81 FALL=10
meas tran tr_13_5 TRIG v(x13_n5) VAL=0.81 RISE=10 TARG v(x13_n5) VAL=0.99 RISE=10
meas tran tf_13_5 TRIG v(x13_n5) VAL=0.99 FALL=10 TARG v(x13_n5) VAL=0.81 FALL=10
meas tran tr_13_6 TRIG v(x13_n6) VAL=0.81 RISE=10 TARG v(x13_n6) VAL=0.99 RISE=10
meas tran tf_13_6 TRIG v(x13_n6) VAL=0.99 FALL=10 TARG v(x13_n6) VAL=0.81 FALL=10
meas tran tr_13_7 TRIG v(x13_n7) VAL=0.81 RISE=10 TARG v(x13_n7) VAL=0.99 RISE=10
meas tran tf_13_7 TRIG v(x13_n7) VAL=0.99 FALL=10 TARG v(x13_n7) VAL=0.81 FALL=10
meas tran tr_13_8 TRIG v(x13_n8) VAL=0.81 RISE=10 TARG v(x13_n8) VAL=0.99 RISE=10
meas tran tf_13_8 TRIG v(x13_n8) VAL=0.99 FALL=10 TARG v(x13_n8) VAL=0.81 FALL=10
meas tran tr_13_9 TRIG v(x13_n9) VAL=0.81 RISE=10 TARG v(x13_n9) VAL=0.99 RISE=10
meas tran tf_13_9 TRIG v(x13_n9) VAL=0.99 FALL=10 TARG v(x13_n9) VAL=0.81 FALL=10
meas tran tr_13_10 TRIG v(x13_n10) VAL=0.81 RISE=10 TARG v(x13_n10) VAL=0.99 RISE=10
meas tran tf_13_10 TRIG v(x13_n10) VAL=0.99 FALL=10 TARG v(x13_n10) VAL=0.81 FALL=10
meas tran tr_13_11 TRIG v(x13_n11) VAL=0.81 RISE=10 TARG v(x13_n11) VAL=0.99 RISE=10
meas tran tf_13_11 TRIG v(x13_n11) VAL=0.99 FALL=10 TARG v(x13_n11) VAL=0.81 FALL=10
meas tran tr_13_12 TRIG v(x13_n12) VAL=0.81 RISE=10 TARG v(x13_n12) VAL=0.99 RISE=10
meas tran tf_13_12 TRIG v(x13_n12) VAL=0.99 FALL=10 TARG v(x13_n12) VAL=0.81 FALL=10
meas tran tr_13_13 TRIG v(x13_n13) VAL=0.81 RISE=10 TARG v(x13_n13) VAL=0.99 RISE=10
meas tran tf_13_13 TRIG v(x13_n13) VAL=0.99 FALL=10 TARG v(x13_n13) VAL=0.81 FALL=10
meas tran tr_13_14 TRIG v(x13_n14) VAL=0.81 RISE=10 TARG v(x13_n14) VAL=0.99 RISE=10
meas tran tf_13_14 TRIG v(x13_n14) VAL=0.99 FALL=10 TARG v(x13_n14) VAL=0.81 FALL=10
meas tran tr_13_15 TRIG v(x13_n15) VAL=0.81 RISE=10 TARG v(x13_n15) VAL=0.99 RISE=10
meas tran tf_13_15 TRIG v(x13_n15) VAL=0.99 FALL=10 TARG v(x13_n15) VAL=0.81 FALL=10
meas tran tr_13_16 TRIG v(x13_n16) VAL=0.81 RISE=10 TARG v(x13_n16) VAL=0.99 RISE=10
meas tran tf_13_16 TRIG v(x13_n16) VAL=0.99 FALL=10 TARG v(x13_n16) VAL=0.81 FALL=10
meas tran tr_13_17 TRIG v(x13_n17) VAL=0.81 RISE=10 TARG v(x13_n17) VAL=0.99 RISE=10
meas tran tf_13_17 TRIG v(x13_n17) VAL=0.99 FALL=10 TARG v(x13_n17) VAL=0.81 FALL=10
meas tran tr_13_18 TRIG v(x13_n18) VAL=0.81 RISE=10 TARG v(x13_n18) VAL=0.99 RISE=10
meas tran tf_13_18 TRIG v(x13_n18) VAL=0.99 FALL=10 TARG v(x13_n18) VAL=0.81 FALL=10
meas tran tr_13_19 TRIG v(x13_n19) VAL=0.81 RISE=10 TARG v(x13_n19) VAL=0.99 RISE=10
meas tran tf_13_19 TRIG v(x13_n19) VAL=0.99 FALL=10 TARG v(x13_n19) VAL=0.81 FALL=10
meas tran tr_13_20 TRIG v(x13_n20) VAL=0.81 RISE=10 TARG v(x13_n20) VAL=0.99 RISE=10
meas tran tf_13_20 TRIG v(x13_n20) VAL=0.99 FALL=10 TARG v(x13_n20) VAL=0.81 FALL=10
meas tran tr_13_21 TRIG v(x13_n21) VAL=0.81 RISE=10 TARG v(x13_n21) VAL=0.99 RISE=10
meas tran tf_13_21 TRIG v(x13_n21) VAL=0.99 FALL=10 TARG v(x13_n21) VAL=0.81 FALL=10
meas tran tr_13_22 TRIG v(x13_n22) VAL=0.81 RISE=10 TARG v(x13_n22) VAL=0.99 RISE=10
meas tran tf_13_22 TRIG v(x13_n22) VAL=0.99 FALL=10 TARG v(x13_n22) VAL=0.81 FALL=10
meas tran tr_13_23 TRIG v(x13_n23) VAL=0.81 RISE=10 TARG v(x13_n23) VAL=0.99 RISE=10
meas tran tf_13_23 TRIG v(x13_n23) VAL=0.99 FALL=10 TARG v(x13_n23) VAL=0.81 FALL=10
meas tran tr_13_24 TRIG v(x13_n24) VAL=0.81 RISE=10 TARG v(x13_n24) VAL=0.99 RISE=10
meas tran tf_13_24 TRIG v(x13_n24) VAL=0.99 FALL=10 TARG v(x13_n24) VAL=0.81 FALL=10
meas tran tr_13_25 TRIG v(x13_n25) VAL=0.81 RISE=10 TARG v(x13_n25) VAL=0.99 RISE=10
meas tran tf_13_25 TRIG v(x13_n25) VAL=0.99 FALL=10 TARG v(x13_n25) VAL=0.81 FALL=10
meas tran tr_13_26 TRIG v(x13_n26) VAL=0.81 RISE=10 TARG v(x13_n26) VAL=0.99 RISE=10
meas tran tf_13_26 TRIG v(x13_n26) VAL=0.99 FALL=10 TARG v(x13_n26) VAL=0.81 FALL=10
meas tran tr_13_27 TRIG v(x13_n27) VAL=0.81 RISE=10 TARG v(x13_n27) VAL=0.99 RISE=10
meas tran tf_13_27 TRIG v(x13_n27) VAL=0.99 FALL=10 TARG v(x13_n27) VAL=0.81 FALL=10
meas tran tr_13_28 TRIG v(x13_n28) VAL=0.81 RISE=10 TARG v(x13_n28) VAL=0.99 RISE=10
meas tran tf_13_28 TRIG v(x13_n28) VAL=0.99 FALL=10 TARG v(x13_n28) VAL=0.81 FALL=10
meas tran tr_13_29 TRIG v(x13_n29) VAL=0.81 RISE=10 TARG v(x13_n29) VAL=0.99 RISE=10
meas tran tf_13_29 TRIG v(x13_n29) VAL=0.99 FALL=10 TARG v(x13_n29) VAL=0.81 FALL=10
meas tran tr_13_30 TRIG v(x13_n30) VAL=0.81 RISE=10 TARG v(x13_n30) VAL=0.99 RISE=10
meas tran tf_13_30 TRIG v(x13_n30) VAL=0.99 FALL=10 TARG v(x13_n30) VAL=0.81 FALL=10
meas tran tr_14_0 TRIG v(x14_n0) VAL=0.81 RISE=10 TARG v(x14_n0) VAL=0.99 RISE=10
meas tran tf_14_0 TRIG v(x14_n0) VAL=0.99 FALL=10 TARG v(x14_n0) VAL=0.81 FALL=10
meas tran tr_14_1 TRIG v(x14_n1) VAL=0.81 RISE=10 TARG v(x14_n1) VAL=0.99 RISE=10
meas tran tf_14_1 TRIG v(x14_n1) VAL=0.99 FALL=10 TARG v(x14_n1) VAL=0.81 FALL=10
meas tran tr_14_2 TRIG v(x14_n2) VAL=0.81 RISE=10 TARG v(x14_n2) VAL=0.99 RISE=10
meas tran tf_14_2 TRIG v(x14_n2) VAL=0.99 FALL=10 TARG v(x14_n2) VAL=0.81 FALL=10
meas tran tr_14_3 TRIG v(x14_n3) VAL=0.81 RISE=10 TARG v(x14_n3) VAL=0.99 RISE=10
meas tran tf_14_3 TRIG v(x14_n3) VAL=0.99 FALL=10 TARG v(x14_n3) VAL=0.81 FALL=10
meas tran tr_14_4 TRIG v(x14_n4) VAL=0.81 RISE=10 TARG v(x14_n4) VAL=0.99 RISE=10
meas tran tf_14_4 TRIG v(x14_n4) VAL=0.99 FALL=10 TARG v(x14_n4) VAL=0.81 FALL=10
meas tran tr_14_5 TRIG v(x14_n5) VAL=0.81 RISE=10 TARG v(x14_n5) VAL=0.99 RISE=10
meas tran tf_14_5 TRIG v(x14_n5) VAL=0.99 FALL=10 TARG v(x14_n5) VAL=0.81 FALL=10
meas tran tr_14_6 TRIG v(x14_n6) VAL=0.81 RISE=10 TARG v(x14_n6) VAL=0.99 RISE=10
meas tran tf_14_6 TRIG v(x14_n6) VAL=0.99 FALL=10 TARG v(x14_n6) VAL=0.81 FALL=10
meas tran tr_14_7 TRIG v(x14_n7) VAL=0.81 RISE=10 TARG v(x14_n7) VAL=0.99 RISE=10
meas tran tf_14_7 TRIG v(x14_n7) VAL=0.99 FALL=10 TARG v(x14_n7) VAL=0.81 FALL=10
meas tran tr_14_8 TRIG v(x14_n8) VAL=0.81 RISE=10 TARG v(x14_n8) VAL=0.99 RISE=10
meas tran tf_14_8 TRIG v(x14_n8) VAL=0.99 FALL=10 TARG v(x14_n8) VAL=0.81 FALL=10
meas tran tr_14_9 TRIG v(x14_n9) VAL=0.81 RISE=10 TARG v(x14_n9) VAL=0.99 RISE=10
meas tran tf_14_9 TRIG v(x14_n9) VAL=0.99 FALL=10 TARG v(x14_n9) VAL=0.81 FALL=10
meas tran tr_14_10 TRIG v(x14_n10) VAL=0.81 RISE=10 TARG v(x14_n10) VAL=0.99 RISE=10
meas tran tf_14_10 TRIG v(x14_n10) VAL=0.99 FALL=10 TARG v(x14_n10) VAL=0.81 FALL=10
meas tran tr_14_11 TRIG v(x14_n11) VAL=0.81 RISE=10 TARG v(x14_n11) VAL=0.99 RISE=10
meas tran tf_14_11 TRIG v(x14_n11) VAL=0.99 FALL=10 TARG v(x14_n11) VAL=0.81 FALL=10
meas tran tr_14_12 TRIG v(x14_n12) VAL=0.81 RISE=10 TARG v(x14_n12) VAL=0.99 RISE=10
meas tran tf_14_12 TRIG v(x14_n12) VAL=0.99 FALL=10 TARG v(x14_n12) VAL=0.81 FALL=10
meas tran tr_14_13 TRIG v(x14_n13) VAL=0.81 RISE=10 TARG v(x14_n13) VAL=0.99 RISE=10
meas tran tf_14_13 TRIG v(x14_n13) VAL=0.99 FALL=10 TARG v(x14_n13) VAL=0.81 FALL=10
meas tran tr_14_14 TRIG v(x14_n14) VAL=0.81 RISE=10 TARG v(x14_n14) VAL=0.99 RISE=10
meas tran tf_14_14 TRIG v(x14_n14) VAL=0.99 FALL=10 TARG v(x14_n14) VAL=0.81 FALL=10
meas tran tr_14_15 TRIG v(x14_n15) VAL=0.81 RISE=10 TARG v(x14_n15) VAL=0.99 RISE=10
meas tran tf_14_15 TRIG v(x14_n15) VAL=0.99 FALL=10 TARG v(x14_n15) VAL=0.81 FALL=10
meas tran tr_14_16 TRIG v(x14_n16) VAL=0.81 RISE=10 TARG v(x14_n16) VAL=0.99 RISE=10
meas tran tf_14_16 TRIG v(x14_n16) VAL=0.99 FALL=10 TARG v(x14_n16) VAL=0.81 FALL=10
meas tran tr_14_17 TRIG v(x14_n17) VAL=0.81 RISE=10 TARG v(x14_n17) VAL=0.99 RISE=10
meas tran tf_14_17 TRIG v(x14_n17) VAL=0.99 FALL=10 TARG v(x14_n17) VAL=0.81 FALL=10
meas tran tr_14_18 TRIG v(x14_n18) VAL=0.81 RISE=10 TARG v(x14_n18) VAL=0.99 RISE=10
meas tran tf_14_18 TRIG v(x14_n18) VAL=0.99 FALL=10 TARG v(x14_n18) VAL=0.81 FALL=10
meas tran tr_14_19 TRIG v(x14_n19) VAL=0.81 RISE=10 TARG v(x14_n19) VAL=0.99 RISE=10
meas tran tf_14_19 TRIG v(x14_n19) VAL=0.99 FALL=10 TARG v(x14_n19) VAL=0.81 FALL=10
meas tran tr_14_20 TRIG v(x14_n20) VAL=0.81 RISE=10 TARG v(x14_n20) VAL=0.99 RISE=10
meas tran tf_14_20 TRIG v(x14_n20) VAL=0.99 FALL=10 TARG v(x14_n20) VAL=0.81 FALL=10
meas tran tr_14_21 TRIG v(x14_n21) VAL=0.81 RISE=10 TARG v(x14_n21) VAL=0.99 RISE=10
meas tran tf_14_21 TRIG v(x14_n21) VAL=0.99 FALL=10 TARG v(x14_n21) VAL=0.81 FALL=10
meas tran tr_14_22 TRIG v(x14_n22) VAL=0.81 RISE=10 TARG v(x14_n22) VAL=0.99 RISE=10
meas tran tf_14_22 TRIG v(x14_n22) VAL=0.99 FALL=10 TARG v(x14_n22) VAL=0.81 FALL=10
meas tran tr_14_23 TRIG v(x14_n23) VAL=0.81 RISE=10 TARG v(x14_n23) VAL=0.99 RISE=10
meas tran tf_14_23 TRIG v(x14_n23) VAL=0.99 FALL=10 TARG v(x14_n23) VAL=0.81 FALL=10
meas tran tr_14_24 TRIG v(x14_n24) VAL=0.81 RISE=10 TARG v(x14_n24) VAL=0.99 RISE=10
meas tran tf_14_24 TRIG v(x14_n24) VAL=0.99 FALL=10 TARG v(x14_n24) VAL=0.81 FALL=10
meas tran tr_14_25 TRIG v(x14_n25) VAL=0.81 RISE=10 TARG v(x14_n25) VAL=0.99 RISE=10
meas tran tf_14_25 TRIG v(x14_n25) VAL=0.99 FALL=10 TARG v(x14_n25) VAL=0.81 FALL=10
meas tran tr_14_26 TRIG v(x14_n26) VAL=0.81 RISE=10 TARG v(x14_n26) VAL=0.99 RISE=10
meas tran tf_14_26 TRIG v(x14_n26) VAL=0.99 FALL=10 TARG v(x14_n26) VAL=0.81 FALL=10
meas tran tr_14_27 TRIG v(x14_n27) VAL=0.81 RISE=10 TARG v(x14_n27) VAL=0.99 RISE=10
meas tran tf_14_27 TRIG v(x14_n27) VAL=0.99 FALL=10 TARG v(x14_n27) VAL=0.81 FALL=10
meas tran tr_14_28 TRIG v(x14_n28) VAL=0.81 RISE=10 TARG v(x14_n28) VAL=0.99 RISE=10
meas tran tf_14_28 TRIG v(x14_n28) VAL=0.99 FALL=10 TARG v(x14_n28) VAL=0.81 FALL=10
meas tran tr_14_29 TRIG v(x14_n29) VAL=0.81 RISE=10 TARG v(x14_n29) VAL=0.99 RISE=10
meas tran tf_14_29 TRIG v(x14_n29) VAL=0.99 FALL=10 TARG v(x14_n29) VAL=0.81 FALL=10
meas tran tr_14_30 TRIG v(x14_n30) VAL=0.81 RISE=10 TARG v(x14_n30) VAL=0.99 RISE=10
meas tran tf_14_30 TRIG v(x14_n30) VAL=0.99 FALL=10 TARG v(x14_n30) VAL=0.81 FALL=10
.endc
.end
