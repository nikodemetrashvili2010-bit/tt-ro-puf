* ro_macro_hard: distributed RC from the macro SPEF
* auto-generated by gen_macro_rc_deck.py
.lib "/home/pc/pdks/sky130A/libs.tech/ngspice/sky130.lib.spice" tt
.include "/home/pc/pdks/sky130A/libs.ref/sky130_fd_sc_hd/spice/sky130_fd_sc_hd.spice"
.param SUPPLY=1.8
Vdd VPWR 0 {SUPPLY}
Ven EN 0 PULSE(0 1.8 2n 50p 50p 1 2)

* --- ro_macro_hard: input delay, nand, 30 inverters, tap buf, output delay ---
Xdly1 dly1_A 0 0 VPWR VPWR dly1_X sky130_fd_sc_hd__clkdlybuf4s25_1
Xnand nand_A nand_B 0 0 VPWR VPWR nand_Y sky130_fd_sc_hd__nand2_1
Xi1 i1_A 0 0 VPWR VPWR i1_Y sky130_fd_sc_hd__inv_1
Xi2 i2_A 0 0 VPWR VPWR i2_Y sky130_fd_sc_hd__inv_1
Xi3 i3_A 0 0 VPWR VPWR i3_Y sky130_fd_sc_hd__inv_1
Xi4 i4_A 0 0 VPWR VPWR i4_Y sky130_fd_sc_hd__inv_1
Xi5 i5_A 0 0 VPWR VPWR i5_Y sky130_fd_sc_hd__inv_1
Xi6 i6_A 0 0 VPWR VPWR i6_Y sky130_fd_sc_hd__inv_1
Xi7 i7_A 0 0 VPWR VPWR i7_Y sky130_fd_sc_hd__inv_1
Xi8 i8_A 0 0 VPWR VPWR i8_Y sky130_fd_sc_hd__inv_1
Xi9 i9_A 0 0 VPWR VPWR i9_Y sky130_fd_sc_hd__inv_1
Xi10 i10_A 0 0 VPWR VPWR i10_Y sky130_fd_sc_hd__inv_1
Xi11 i11_A 0 0 VPWR VPWR i11_Y sky130_fd_sc_hd__inv_1
Xi12 i12_A 0 0 VPWR VPWR i12_Y sky130_fd_sc_hd__inv_1
Xi13 i13_A 0 0 VPWR VPWR i13_Y sky130_fd_sc_hd__inv_1
Xi14 i14_A 0 0 VPWR VPWR i14_Y sky130_fd_sc_hd__inv_1
Xi15 i15_A 0 0 VPWR VPWR i15_Y sky130_fd_sc_hd__inv_1
Xi16 i16_A 0 0 VPWR VPWR i16_Y sky130_fd_sc_hd__inv_1
Xi17 i17_A 0 0 VPWR VPWR i17_Y sky130_fd_sc_hd__inv_1
Xi18 i18_A 0 0 VPWR VPWR i18_Y sky130_fd_sc_hd__inv_1
Xi19 i19_A 0 0 VPWR VPWR i19_Y sky130_fd_sc_hd__inv_1
Xi20 i20_A 0 0 VPWR VPWR i20_Y sky130_fd_sc_hd__inv_1
Xi21 i21_A 0 0 VPWR VPWR i21_Y sky130_fd_sc_hd__inv_1
Xi22 i22_A 0 0 VPWR VPWR i22_Y sky130_fd_sc_hd__inv_1
Xi23 i23_A 0 0 VPWR VPWR i23_Y sky130_fd_sc_hd__inv_1
Xi24 i24_A 0 0 VPWR VPWR i24_Y sky130_fd_sc_hd__inv_1
Xi25 i25_A 0 0 VPWR VPWR i25_Y sky130_fd_sc_hd__inv_1
Xi26 i26_A 0 0 VPWR VPWR i26_Y sky130_fd_sc_hd__inv_1
Xi27 i27_A 0 0 VPWR VPWR i27_Y sky130_fd_sc_hd__inv_1
Xi28 i28_A 0 0 VPWR VPWR i28_Y sky130_fd_sc_hd__inv_1
Xi29 i29_A 0 0 VPWR VPWR i29_Y sky130_fd_sc_hd__inv_1
Xi30 i30_A 0 0 VPWR VPWR i30_Y sky130_fd_sc_hd__inv_1
Xbuf buf_A 0 0 VPWR VPWR buf_X sky130_fd_sc_hd__buf_1
Xdly2 dly2_A 0 0 VPWR VPWR dly2_X sky130_fd_sc_hd__clkdlybuf4s25_1

R0 EN dly1_A 25.1750
Cg0 EN 0 5.640700e-16
Cg1 dly1_A 0 5.640700e-16
Cc0 dly1_A nand_B 0.000000e+00
R1 dly1_X nand_A 22.8500
Cg2 nand_A 0 2.541970e-16
Cg3 dly1_X 0 2.541970e-16
R2 buf_X dly2_A 33.3321
Cg4 dly2_A 0 3.682920e-16
Cg5 buf_X 0 3.682920e-16
Cc1 dly2_A i10_A 0.000000e+00
Cc2 dly2_A buf_A 0.000000e+00
R3 dly2_X out 38.9786
Cg6 out 0 9.712870e-16
Cg7 dly2_X 0 9.712870e-16
R4 nand_Y i1_A 29.7830
Cg8 i1_A 0 1.142450e-16
Cg9 nand_Y 0 1.142450e-16
Cc3 i1_A nand_B 7.835870e-17
R5 i10_Y i11_A 19.4973
Cg10 i11_A 0 5.339630e-17
Cg11 i10_Y 0 5.339630e-17
R6 i11_Y i12_A 19.4973
Cg12 i12_A 0 5.339630e-17
Cg13 i11_Y 0 5.339630e-17
R7 i12_Y i13_A 19.4973
Cg14 i13_A 0 6.167360e-17
Cg15 i12_Y 0 6.167360e-17
R8 i13_Y i14_A 19.4973
Cg16 i14_A 0 5.339630e-17
Cg17 i13_Y 0 5.339630e-17
R9 i14_Y i15_A 19.4973
Cg18 i15_A 0 4.248980e-17
Cg19 i14_Y 0 4.248980e-17
Cc4 i15_A buf_A 3.819630e-17
R10 i15_Y s13_4 9.3000
R11 s13_4 i16_A 10.9295
R12 s13_4 buf_A 21.0946
Cg20 buf_A 0 1.893520e-16
Cg21 i16_A 0 8.781620e-17
Cg22 i15_Y 0 0.000000e+00
Cg23 s13_4 0 2.771690e-16
Cc5 buf_A i18_A 0.000000e+00
R13 i16_Y i17_A 19.8634
Cg24 i17_A 0 5.056460e-17
Cg25 i16_Y 0 5.056460e-17
Cc6 i17_A i18_A 5.095420e-17
Cc7 i17_A i20_A 6.673960e-17
R14 i17_Y i18_A 30.6313
Cg26 i18_A 0 1.974810e-16
Cg27 i17_Y 0 1.974810e-16
Cc8 i18_A i20_A 5.725460e-17
R15 i18_Y i19_A 32.3187
Cg28 i19_A 0 3.500300e-16
Cg29 i18_Y 0 3.500300e-16
Cc9 i19_A i20_A 1.374110e-17
Cc10 i19_A i21_A 7.279340e-17
R16 i19_Y i20_A 31.9973
Cg30 i20_A 0 2.457020e-16
Cg31 i19_Y 0 2.457020e-16
R17 i1_Y i2_A 20.3545
Cg32 i2_A 0 1.127960e-16
Cg33 i1_Y 0 1.127960e-16
R18 i20_Y i21_A 19.8634
Cg34 i21_A 0 4.151100e-17
Cg35 i20_Y 0 4.151100e-17
Cc11 i21_A i22_A 2.627400e-17
R19 i21_Y i22_A 30.5688
Cg36 i22_A 0 1.985070e-16
Cg37 i21_Y 0 1.985070e-16
R20 i22_Y i23_A 19.4973
Cg38 i23_A 0 5.203440e-17
Cg39 i22_Y 0 5.203440e-17
Cc12 i23_A i25_A 1.377430e-17
R21 i23_Y i24_A 19.8634
Cg40 i24_A 0 5.334180e-17
Cg41 i23_Y 0 5.334180e-17
Cc13 i24_A i25_A 5.629950e-17
R22 i24_Y i25_A 33.3902
Cg42 i25_A 0 3.511060e-16
Cg43 i24_Y 0 3.511060e-16
Cc14 i25_A i26_A 9.479740e-17
Cc15 i25_A i27_A 1.038180e-17
R23 i25_Y i26_A 19.4973
Cg44 i26_A 0 3.134850e-17
Cg45 i25_Y 0 3.134850e-17
R24 i26_Y i27_A 32.1670
Cg46 i27_A 0 3.143930e-16
Cg47 i26_Y 0 3.143930e-16
Cc16 i27_A i28_A 3.040590e-17
Cc17 i27_A i29_A 1.000690e-16
Cc18 i27_A nand_B 0.000000e+00
R25 i27_Y i28_A 30.9348
Cg48 i28_A 0 2.291480e-16
Cg49 i27_Y 0 2.291480e-16
R26 i28_Y i29_A 20.2429
Cg50 i29_A 0 6.906400e-17
Cg51 i28_Y 0 6.906400e-17
R27 i29_Y i30_A 19.4973
Cg52 i30_A 0 5.405960e-17
Cg53 i29_Y 0 5.405960e-17
R28 i2_Y i3_A 19.4973
Cg54 i3_A 0 5.339630e-17
Cg55 i2_Y 0 5.339630e-17
R29 i30_Y nand_B 31.5196
Cg56 nand_B 0 2.686430e-16
Cg57 i30_Y 0 2.686430e-16
R30 i3_Y i4_A 31.9080
Cg58 i4_A 0 3.296170e-16
Cg59 i3_Y 0 3.296170e-16
R31 i4_Y i5_A 22.1045
Cg60 i5_A 0 1.793090e-16
Cg61 i4_Y 0 1.793090e-16
Cc19 i5_A i6_A 1.347720e-16
R32 i5_Y i6_A 19.8634
Cg62 i6_A 0 2.966920e-17
Cg63 i5_Y 0 2.966920e-17
Cc20 i6_A i7_A 3.145920e-17
R33 i6_Y i7_A 31.4170
Cg64 i7_A 0 2.305410e-16
Cg65 i6_Y 0 2.305410e-16
Cc21 i7_A i10_A 6.051610e-18
Cc22 i7_A i8_A 7.713030e-17
R34 i7_Y i8_A 22.1045
Cg66 i8_A 0 1.602520e-16
Cg67 i7_Y 0 1.602520e-16
Cc23 i8_A i10_A 6.882400e-18
Cc24 i8_A i9_A 9.572150e-17
R35 i8_Y i9_A 19.4973
Cg68 i9_A 0 3.355400e-17
Cg69 i8_Y 0 3.355400e-17
R36 i9_Y i10_A 29.8545
Cg70 i10_A 0 1.529170e-16
Cg71 i9_Y 0 1.529170e-16

.save v(out)
.tran 1p 140n
.control
run
meas tran tp TRIG v(out) VAL=0.9 RISE=5 TARG v(out) VAL=0.9 RISE=25
let f = 20 / tp
print f
.endc
.end
