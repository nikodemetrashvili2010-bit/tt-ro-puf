* ro_macro_hard: lumped D_NET caps
* auto-generated by gen_macro_rc_deck.py
.lib "/home/pc/pdks/sky130A/libs.tech/ngspice/sky130.lib.spice" tt
.include "/home/pc/pdks/sky130A/libs.ref/sky130_fd_sc_hd/spice/sky130_fd_sc_hd.spice"
.param SUPPLY=1.8
Vdd VPWR 0 {SUPPLY}
Ven EN 0 PULSE(0 1.8 2n 50p 50p 1 2)

* --- ro_macro_hard: input delay, nand, 30 inverters, tap buf, output delay ---
Xdly1 EN 0 0 VPWR VPWR net1 sky130_fd_sc_hd__clkdlybuf4s25_1
Xnand net1 n30 0 0 VPWR VPWR n0 sky130_fd_sc_hd__nand2_1
Xi1 n0 0 0 VPWR VPWR n1 sky130_fd_sc_hd__inv_1
Xi2 n1 0 0 VPWR VPWR n2 sky130_fd_sc_hd__inv_1
Xi3 n2 0 0 VPWR VPWR n3 sky130_fd_sc_hd__inv_1
Xi4 n3 0 0 VPWR VPWR n4 sky130_fd_sc_hd__inv_1
Xi5 n4 0 0 VPWR VPWR n5 sky130_fd_sc_hd__inv_1
Xi6 n5 0 0 VPWR VPWR n6 sky130_fd_sc_hd__inv_1
Xi7 n6 0 0 VPWR VPWR n7 sky130_fd_sc_hd__inv_1
Xi8 n7 0 0 VPWR VPWR n8 sky130_fd_sc_hd__inv_1
Xi9 n8 0 0 VPWR VPWR n9 sky130_fd_sc_hd__inv_1
Xi10 n9 0 0 VPWR VPWR n10 sky130_fd_sc_hd__inv_1
Xi11 n10 0 0 VPWR VPWR n11 sky130_fd_sc_hd__inv_1
Xi12 n11 0 0 VPWR VPWR n12 sky130_fd_sc_hd__inv_1
Xi13 n12 0 0 VPWR VPWR n13 sky130_fd_sc_hd__inv_1
Xi14 n13 0 0 VPWR VPWR n14 sky130_fd_sc_hd__inv_1
Xi15 n14 0 0 VPWR VPWR n15 sky130_fd_sc_hd__inv_1
Xi16 n15 0 0 VPWR VPWR n16 sky130_fd_sc_hd__inv_1
Xi17 n16 0 0 VPWR VPWR n17 sky130_fd_sc_hd__inv_1
Xi18 n17 0 0 VPWR VPWR n18 sky130_fd_sc_hd__inv_1
Xi19 n18 0 0 VPWR VPWR n19 sky130_fd_sc_hd__inv_1
Xi20 n19 0 0 VPWR VPWR n20 sky130_fd_sc_hd__inv_1
Xi21 n20 0 0 VPWR VPWR n21 sky130_fd_sc_hd__inv_1
Xi22 n21 0 0 VPWR VPWR n22 sky130_fd_sc_hd__inv_1
Xi23 n22 0 0 VPWR VPWR n23 sky130_fd_sc_hd__inv_1
Xi24 n23 0 0 VPWR VPWR n24 sky130_fd_sc_hd__inv_1
Xi25 n24 0 0 VPWR VPWR n25 sky130_fd_sc_hd__inv_1
Xi26 n25 0 0 VPWR VPWR n26 sky130_fd_sc_hd__inv_1
Xi27 n26 0 0 VPWR VPWR n27 sky130_fd_sc_hd__inv_1
Xi28 n27 0 0 VPWR VPWR n28 sky130_fd_sc_hd__inv_1
Xi29 n28 0 0 VPWR VPWR n29 sky130_fd_sc_hd__inv_1
Xi30 n29 0 0 VPWR VPWR n30 sky130_fd_sc_hd__inv_1
Xbuf n15 0 0 VPWR VPWR net2 sky130_fd_sc_hd__buf_1
Xdly2 net2 0 0 VPWR VPWR out sky130_fd_sc_hd__clkdlybuf4s25_1

CEN_tot EN 0 1.128140e-15
Cnet1_tot net1 0 5.083940e-16
Cnet2_tot net2 0 7.365850e-16
Cout_tot out 0 1.942570e-15
Cn0_tot n0 0 3.068490e-16
Cn10_tot n10 0 1.067930e-16
Cn11_tot n11 0 1.067930e-16
Cn12_tot n12 0 1.233470e-16
Cn13_tot n13 0 1.067930e-16
Cn14_tot n14 0 1.231760e-16
Cn15_tot n15 0 5.925330e-16
Cn16_tot n16 0 2.188230e-16
Cn17_tot n17 0 5.031700e-16
Cn18_tot n18 0 7.865940e-16
Cn19_tot n19 0 6.291400e-16
Cn1_tot n1 0 2.255910e-16
Cn20_tot n20 0 1.820890e-16
Cn21_tot n21 0 4.232880e-16
Cn22_tot n22 0 1.178430e-16
Cn23_tot n23 0 1.629830e-16
Cn24_tot n24 0 8.774660e-16
Cn25_tot n25 0 1.574940e-16
Cn26_tot n26 0 7.696420e-16
Cn27_tot n27 0 4.887020e-16
Cn28_tot n28 0 2.381970e-16
Cn29_tot n29 0 1.081190e-16
Cn2_tot n2 0 1.067930e-16
Cn30_tot n30 0 6.156450e-16
Cn3_tot n3 0 6.592350e-16
Cn4_tot n4 0 4.933900e-16
Cn5_tot n5 0 2.255700e-16
Cn6_tot n6 0 5.757220e-16
Cn7_tot n7 0 5.002390e-16
Cn8_tot n8 0 1.628300e-16
Cn9_tot n9 0 3.187680e-16

.save v(out)
.tran 1p 140n
.control
run
meas tran tp TRIG v(out) VAL=0.9 RISE=5 TARG v(out) VAL=0.9 RISE=25
let f = 20 / tp
print f
.endc
.end
