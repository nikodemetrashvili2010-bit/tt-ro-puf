* Arm C oscillator 1: distributed RC from SPEF
* auto-generated by gen_rc_decks.py
.lib "/home/claude/w/pdk/sky130A/libs.tech/ngspice/sky130.lib.spice" tt
.include "/home/claude/w/pdk/sky130A/libs.ref/sky130_fd_sc_hd/spice/sky130_fd_sc_hd.spice"
.param SUPPLY=1.8
Vdd VPWR 0 {SUPPLY}
Ven EN 0 PULSE(0 1.8 2n 50p 50p 1 2)

* --- Arm C oscillator 1: nand + 30 inverters + tap buffer ---
Xnand EN nand_B 0 0 VPWR VPWR nand_Y sky130_fd_sc_hd__nand2_1
Xi1 i1_A 0 0 VPWR VPWR i1_Y sky130_fd_sc_hd__inv_1
Xi2 i2_A 0 0 VPWR VPWR i2_Y sky130_fd_sc_hd__inv_1
Xi3 i3_A 0 0 VPWR VPWR i3_Y sky130_fd_sc_hd__inv_1
Xi4 i4_A 0 0 VPWR VPWR i4_Y sky130_fd_sc_hd__inv_1
Xi5 i5_A 0 0 VPWR VPWR i5_Y sky130_fd_sc_hd__inv_1
Xi6 i6_A 0 0 VPWR VPWR i6_Y sky130_fd_sc_hd__inv_1
Xi7 i7_A 0 0 VPWR VPWR i7_Y sky130_fd_sc_hd__inv_1
Xi8 i8_A 0 0 VPWR VPWR i8_Y sky130_fd_sc_hd__inv_1
Xi9 i9_A 0 0 VPWR VPWR i9_Y sky130_fd_sc_hd__inv_1
Xi10 i10_A 0 0 VPWR VPWR i10_Y sky130_fd_sc_hd__inv_1
Xi11 i11_A 0 0 VPWR VPWR i11_Y sky130_fd_sc_hd__inv_1
Xi12 i12_A 0 0 VPWR VPWR i12_Y sky130_fd_sc_hd__inv_1
Xi13 i13_A 0 0 VPWR VPWR i13_Y sky130_fd_sc_hd__inv_1
Xi14 i14_A 0 0 VPWR VPWR i14_Y sky130_fd_sc_hd__inv_1
Xi15 i15_A 0 0 VPWR VPWR i15_Y sky130_fd_sc_hd__inv_1
Xi16 i16_A 0 0 VPWR VPWR i16_Y sky130_fd_sc_hd__inv_1
Xi17 i17_A 0 0 VPWR VPWR i17_Y sky130_fd_sc_hd__inv_1
Xi18 i18_A 0 0 VPWR VPWR i18_Y sky130_fd_sc_hd__inv_1
Xi19 i19_A 0 0 VPWR VPWR i19_Y sky130_fd_sc_hd__inv_1
Xi20 i20_A 0 0 VPWR VPWR i20_Y sky130_fd_sc_hd__inv_1
Xi21 i21_A 0 0 VPWR VPWR i21_Y sky130_fd_sc_hd__inv_1
Xi22 i22_A 0 0 VPWR VPWR i22_Y sky130_fd_sc_hd__inv_1
Xi23 i23_A 0 0 VPWR VPWR i23_Y sky130_fd_sc_hd__inv_1
Xi24 i24_A 0 0 VPWR VPWR i24_Y sky130_fd_sc_hd__inv_1
Xi25 i25_A 0 0 VPWR VPWR i25_Y sky130_fd_sc_hd__inv_1
Xi26 i26_A 0 0 VPWR VPWR i26_Y sky130_fd_sc_hd__inv_1
Xi27 i27_A 0 0 VPWR VPWR i27_Y sky130_fd_sc_hd__inv_1
Xi28 i28_A 0 0 VPWR VPWR i28_Y sky130_fd_sc_hd__inv_1
Xi29 i29_A 0 0 VPWR VPWR i29_Y sky130_fd_sc_hd__inv_1
Xi30 i30_A 0 0 VPWR VPWR i30_Y sky130_fd_sc_hd__inv_1
Xbuf buf_A 0 0 VPWR VPWR buf_X sky130_fd_sc_hd__buf_1

Rn0_0 nand_Y i1_A 20.2563
Cg0 i1_A 0 4.943080e-17
Cg1 nand_Y 0 4.943080e-17
Cc0 EN i1_A 3.932470e-17
Cx0 i1_A 0 6.881750e-17
Cx1 i1_A 0 2.702410e-17
Rn1_1 i1_Y i2_A 19.4973
Cg2 i2_A 0 1.284900e-17
Cg3 i1_Y 0 1.284900e-17
Cx2 i2_A 0 9.572150e-17
Cx3 i2_A 0 5.337830e-17
Rn10_2 i10_Y i11_A 20.8277
Cg4 i11_A 0 7.010060e-17
Cg5 i10_Y 0 7.010060e-17
Cc1 i11_A i12_A 3.902610e-17
Cc2 i11_A i9_A 0.000000e+00
Cc3 i11_A i10_A 2.986910e-17
Cx4 i11_A 0 6.964510e-17
Rn11_3 i11_Y i12_A 21.1313
Cg6 i12_A 0 7.330480e-17
Cg7 i11_Y 0 7.330480e-17
Cc4 i12_A i13_A 3.028690e-17
Cc5 i12_A i14_A 0.000000e+00
Cx5 i12_A 0 1.450400e-16
Rn12_4 i12_Y i13_A 21.3813
Cg8 i13_A 0 1.310300e-16
Cg9 i12_Y 0 1.310300e-16
Cc6 i13_A i14_A 3.028690e-17
Cc7 i13_A i15_A 0.000000e+00
Cc8 i13_A i10_A 0.000000e+00
Cx6 i13_A 0 2.417650e-17
Rn13_5 i13_Y i14_A 21.1313
Cg10 i14_A 0 7.534660e-17
Cg11 i13_Y 0 7.534660e-17
Cc9 i14_A i15_A 3.028690e-17
Cx7 i14_A 0 1.508060e-16
Rn14_6 i14_Y i15_A 21.3813
Cg12 i15_A 0 1.425840e-16
Cg13 i14_Y 0 1.425840e-16
Cx8 i15_A 0 5.334430e-17
Rn15_7 i15_Y s881_12 20.5768
Rn15_8 s881_12 buf_A 9.8357
Rn15_9 s881_12 i16_A 10.4027
Cg14 i16_A 0 3.206730e-17
Cg15 buf_A 0 2.250530e-17
Cg16 i15_Y 0 7.243970e-17
Cg17 s881_12 0 1.270120e-16
Cc10 s881_12 nand_B 1.506180e-16
Cx9 s881_12 0 3.479200e-17
Cx10 i16_A 0 1.127620e-16
Cx11 buf_A 0 5.330050e-17
Cx12 i16_A 0 3.435880e-17
Cx13 buf_A 0 1.581630e-17
Cx14 s881_12 0 1.489030e-16
Rn16_10 i16_Y i17_A 19.4973
Cg18 i17_A 0 1.450790e-17
Cg19 i16_Y 0 1.450790e-17
Cx15 i17_A 0 9.572150e-17
Cx16 i17_A 0 3.809220e-17
Rn17_11 i17_Y i18_A 19.4973
Cg20 i18_A 0 1.450790e-17
Cg21 i17_Y 0 1.450790e-17
Cx17 i18_A 0 9.572150e-17
Cx18 i18_A 0 3.809220e-17
Rn18_12 i18_Y i19_A 19.4973
Cg22 i19_A 0 1.450790e-17
Cg23 i18_Y 0 1.450790e-17
Cx19 i19_A 0 9.572150e-17
Cx20 i19_A 0 3.809220e-17
Rn19_13 i19_Y i20_A 19.4973
Cg24 i20_A 0 1.450790e-17
Cg25 i19_Y 0 1.450790e-17
Cx21 i20_A 0 9.572150e-17
Cx22 i20_A 0 3.809220e-17
Rn2_14 i2_Y i3_A 19.4973
Cg26 i3_A 0 1.284900e-17
Cg27 i2_Y 0 1.284900e-17
Cx23 i3_A 0 9.572150e-17
Cx24 i3_A 0 5.337830e-17
Rn20_15 i20_Y i21_A 19.4973
Cg28 i21_A 0 1.450790e-17
Cg29 i20_Y 0 1.450790e-17
Cx25 i21_A 0 9.572150e-17
Cx26 i21_A 0 3.809220e-17
Rn21_16 i21_Y i22_A 19.4973
Cg30 i22_A 0 1.450790e-17
Cg31 i21_Y 0 1.450790e-17
Cx27 i22_A 0 9.572150e-17
Cx28 i22_A 0 3.809220e-17
Rn22_17 i22_Y i23_A 30.2652
Cg32 i23_A 0 1.793350e-16
Cg33 i22_Y 0 1.793350e-16
Cx29 i23_A 0 2.826600e-18
Cc11 i23_A i24_A 2.808530e-17
Cx30 i23_A 0 0.000000e+00
Cx31 i23_A 0 0.000000e+00
Cx32 i23_A 0 1.377430e-17
Cx33 i23_A 0 7.905360e-17
Rn23_18 i23_Y i24_A 20.8277
Cg34 i24_A 0 9.016050e-17
Cg35 i23_Y 0 9.016050e-17
Cc12 i24_A i25_A 4.176180e-17
Cx34 i24_A 0 6.830870e-17
Rn24_19 i24_Y i25_A 21.3813
Cg36 i25_A 0 1.072590e-16
Cg37 i24_Y 0 1.072590e-16
Cc13 i25_A i26_A 4.549590e-17
Cx35 i25_A 0 6.156100e-17
Rn25_20 i25_Y i26_A 21.1313
Cg38 i26_A 0 1.066140e-16
Cg39 i25_Y 0 1.066140e-16
Cc14 i26_A i27_A 5.276310e-17
Cx36 i26_A 0 6.102550e-17
Rn26_21 i26_Y i27_A 21.3813
Cg40 i27_A 0 1.004070e-16
Cg41 i26_Y 0 1.004070e-16
Cc15 i27_A i28_A 5.146670e-17
Cx37 i27_A 0 6.156100e-17
Rn27_22 i27_Y i28_A 21.3813
Cg42 i28_A 0 1.005760e-16
Cg43 i27_Y 0 1.005760e-16
Cc16 i28_A i29_A 5.146670e-17
Cx38 i28_A 0 6.156100e-17
Rn28_23 i28_Y i29_A 21.3813
Cg44 i29_A 0 1.035760e-16
Cg45 i28_Y 0 1.035760e-16
Cc17 i29_A i30_A 4.930640e-17
Cx39 i29_A 0 6.156100e-17
Rn29_24 i29_Y i30_A 21.3813
Cg46 i30_A 0 1.253820e-16
Cg47 i29_Y 0 1.253820e-16
Cc18 i30_A nand_B 2.559870e-17
Cx40 i30_A 0 5.972580e-17
Rn3_25 i3_Y i4_A 19.4973
Cg48 i4_A 0 1.284900e-17
Cg49 i3_Y 0 1.284900e-17
Cx41 i4_A 0 9.572150e-17
Cx42 i4_A 0 5.337830e-17
Rn30_26 i30_Y nand_B 34.8411
Cg50 nand_B 0 2.899690e-16
Cg51 i30_Y 0 2.899690e-16
Cx43 nand_B 0 0.000000e+00
Cx44 nand_B 0 1.498960e-16
Cc19 EN nand_B 9.910860e-17
Cx45 nand_B 0 6.405340e-18
Cx46 nand_B 0 0.000000e+00
Cx47 nand_B 0 1.788930e-16
Rn4_27 i4_Y i5_A 19.4973
Cg52 i5_A 0 1.284900e-17
Cg53 i4_Y 0 1.284900e-17
Cx48 i5_A 0 9.572150e-17
Cx49 i5_A 0 5.337830e-17
Rn5_28 i5_Y i6_A 19.4973
Cg54 i6_A 0 1.284900e-17
Cg55 i5_Y 0 1.284900e-17
Cx50 i6_A 0 9.572150e-17
Cx51 i6_A 0 5.337830e-17
Rn6_29 i6_Y i7_A 19.4973
Cg56 i7_A 0 1.107150e-17
Cg57 i6_Y 0 1.107150e-17
Cx52 i7_A 0 9.572150e-17
Cx53 i7_A 0 8.603100e-17
Rn7_30 i7_Y i8_A 30.2652
Cg58 i8_A 0 1.745940e-16
Cg59 i7_Y 0 1.745940e-16
Cc20 i8_A i9_A 2.808530e-17
Cx54 i8_A 0 0.000000e+00
Cx55 i8_A 0 7.905360e-17
Rn8_31 i8_Y i9_A 20.8277
Cg60 i9_A 0 7.513850e-17
Cg61 i8_Y 0 7.513850e-17
Cc21 i9_A i10_A 2.629080e-17
Cx56 i9_A 0 9.068840e-17
Rn9_32 i9_Y i10_A 21.0732
Cg62 i10_A 0 1.649630e-16
Cg63 i9_Y 0 1.649630e-16
Cx57 i10_A 0 1.000130e-17
Rout_33 buf_X s906_8 16.3893
Rout_34 s906_8 s906_10 59.1696
Rout_35 s906_10 s906_18 46.6161
Cg64 buf_X 0 1.879600e-16
Cg65 s906_18 0 2.156620e-15
Cg66 s906_10 0 4.587570e-15
Cg67 s906_8 0 2.618900e-15
Cx58 s906_10 0 3.425020e-16
Cx59 s906_10 0 9.746840e-17
Cx60 s906_10 0 1.264390e-16
Cx61 s906_10 0 1.691150e-17
Cx62 s906_10 0 9.910860e-17
Cx63 s906_10 0 0.000000e+00
Cx64 s906_10 0 7.082970e-17
Cx65 s906_10 0 4.033180e-17
Cx66 s906_10 0 8.063310e-17
Cx67 s906_10 0 1.305110e-16
Cx68 s906_18 0 0.000000e+00
Cx69 s906_18 0 0.000000e+00
Cx70 s906_18 0 1.240100e-16
Cx71 s906_18 0 0.000000e+00
Cx72 s906_18 0 0.000000e+00
Cx73 s906_18 0 1.334770e-16
Cx74 s906_18 0 1.696830e-16
Cx75 s906_10 0 3.250780e-17
Cx76 s906_10 0 2.927220e-16
Cx77 s906_18 0 0.000000e+00
Cx78 s906_10 0 7.809290e-17
Cx79 s906_8 0 2.684030e-16
Cx80 s906_18 0 3.363550e-18
Cx81 s906_18 0 1.038110e-16
Cx82 s906_10 0 1.513330e-16
Cx83 s906_10 0 1.492020e-15
Cx84 s906_10 0 9.211580e-16
Cx85 s906_18 0 9.547980e-18
Cx86 s906_18 0 1.340060e-15
Cx87 s906_18 0 1.033470e-15
Cx88 s906_10 0 0.000000e+00
Cx89 s906_18 0 0.000000e+00
Cx90 s906_18 0 1.017790e-16
Cx91 s906_18 0 0.000000e+00
Cx92 s906_10 0 5.395380e-16
Cx93 s906_10 0 0.000000e+00
Cx94 s906_18 0 8.435880e-16

.save v(buf_X)
.tran 1p 140n
.control
run
meas tran tp TRIG v(buf_X) VAL=0.9 RISE=5 TARG v(buf_X) VAL=0.9 RISE=25
let f = 20 / tp
print f
.endc
.end
