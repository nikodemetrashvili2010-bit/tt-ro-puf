* Arm C oscillator 12: distributed RC from SPEF
* auto-generated by gen_rc_decks.py
.lib "/home/pc/pdks/sky130A/libs.tech/ngspice/sky130.lib.spice" tt
.include "/home/pc/pdks/sky130A/libs.ref/sky130_fd_sc_hd/spice/sky130_fd_sc_hd.spice"
.param SUPPLY=1.8
Vdd VPWR 0 {SUPPLY}
Ven EN 0 PULSE(0 1.8 2n 50p 50p 1 2)

* --- Arm C oscillator 12: nand + 30 inverters + tap buffer ---
Xnand EN nand_B 0 0 VPWR VPWR nand_Y sky130_fd_sc_hd__nand2_1
Xi1 i1_A 0 0 VPWR VPWR i1_Y sky130_fd_sc_hd__inv_1
Xi2 i2_A 0 0 VPWR VPWR i2_Y sky130_fd_sc_hd__inv_1
Xi3 i3_A 0 0 VPWR VPWR i3_Y sky130_fd_sc_hd__inv_1
Xi4 i4_A 0 0 VPWR VPWR i4_Y sky130_fd_sc_hd__inv_1
Xi5 i5_A 0 0 VPWR VPWR i5_Y sky130_fd_sc_hd__inv_1
Xi6 i6_A 0 0 VPWR VPWR i6_Y sky130_fd_sc_hd__inv_1
Xi7 i7_A 0 0 VPWR VPWR i7_Y sky130_fd_sc_hd__inv_1
Xi8 i8_A 0 0 VPWR VPWR i8_Y sky130_fd_sc_hd__inv_1
Xi9 i9_A 0 0 VPWR VPWR i9_Y sky130_fd_sc_hd__inv_1
Xi10 i10_A 0 0 VPWR VPWR i10_Y sky130_fd_sc_hd__inv_1
Xi11 i11_A 0 0 VPWR VPWR i11_Y sky130_fd_sc_hd__inv_1
Xi12 i12_A 0 0 VPWR VPWR i12_Y sky130_fd_sc_hd__inv_1
Xi13 i13_A 0 0 VPWR VPWR i13_Y sky130_fd_sc_hd__inv_1
Xi14 i14_A 0 0 VPWR VPWR i14_Y sky130_fd_sc_hd__inv_1
Xi15 i15_A 0 0 VPWR VPWR i15_Y sky130_fd_sc_hd__inv_1
Xi16 i16_A 0 0 VPWR VPWR i16_Y sky130_fd_sc_hd__inv_1
Xi17 i17_A 0 0 VPWR VPWR i17_Y sky130_fd_sc_hd__inv_1
Xi18 i18_A 0 0 VPWR VPWR i18_Y sky130_fd_sc_hd__inv_1
Xi19 i19_A 0 0 VPWR VPWR i19_Y sky130_fd_sc_hd__inv_1
Xi20 i20_A 0 0 VPWR VPWR i20_Y sky130_fd_sc_hd__inv_1
Xi21 i21_A 0 0 VPWR VPWR i21_Y sky130_fd_sc_hd__inv_1
Xi22 i22_A 0 0 VPWR VPWR i22_Y sky130_fd_sc_hd__inv_1
Xi23 i23_A 0 0 VPWR VPWR i23_Y sky130_fd_sc_hd__inv_1
Xi24 i24_A 0 0 VPWR VPWR i24_Y sky130_fd_sc_hd__inv_1
Xi25 i25_A 0 0 VPWR VPWR i25_Y sky130_fd_sc_hd__inv_1
Xi26 i26_A 0 0 VPWR VPWR i26_Y sky130_fd_sc_hd__inv_1
Xi27 i27_A 0 0 VPWR VPWR i27_Y sky130_fd_sc_hd__inv_1
Xi28 i28_A 0 0 VPWR VPWR i28_Y sky130_fd_sc_hd__inv_1
Xi29 i29_A 0 0 VPWR VPWR i29_Y sky130_fd_sc_hd__inv_1
Xi30 i30_A 0 0 VPWR VPWR i30_Y sky130_fd_sc_hd__inv_1
Xbuf buf_A 0 0 VPWR VPWR buf_X sky130_fd_sc_hd__buf_1

Rn0_0 nand_Y i1_A 20.2563
Cg0 i1_A 0 6.476240e-17
Cg1 nand_Y 0 6.476240e-17
Cc0 EN i1_A 4.229080e-17
Cx0 i1_A 0 2.885940e-17
Rn1_1 i1_Y i2_A 19.4973
Cg2 i2_A 0 3.269130e-17
Cg3 i1_Y 0 3.269130e-17
Cx1 i2_A 0 5.337830e-17
Rn10_2 i10_Y i11_A 20.8277
Cg4 i11_A 0 1.075470e-16
Cg5 i10_Y 0 1.075470e-16
Cc1 i11_A i12_A 3.000530e-17
Cc2 i11_A i13_A 0.000000e+00
Cc3 i11_A i9_A 0.000000e+00
Cc4 i11_A i10_A 2.922120e-17
Rn11_3 i11_Y i12_A 21.1313
Cg6 i12_A 0 1.239130e-16
Cg7 i11_Y 0 1.239130e-16
Cc5 i12_A i13_A 3.028690e-17
Cc6 i12_A i14_A 0.000000e+00
Cc7 i12_A i10_A 0.000000e+00
Rn12_4 i12_Y i13_A 21.3813
Cg8 i13_A 0 1.417400e-16
Cg9 i12_Y 0 1.417400e-16
Cc8 i13_A i14_A 3.028690e-17
Cc9 i13_A i15_A 0.000000e+00
Rn13_5 i13_Y i14_A 21.1313
Cg10 i14_A 0 1.238470e-16
Cg11 i13_Y 0 1.238470e-16
Cc10 i14_A i15_A 3.028690e-17
Rn14_6 i14_Y i15_A 21.3813
Cg12 i15_A 0 1.463070e-16
Cg13 i14_Y 0 1.463070e-16
Cc11 i15_A s749_12 1.402400e-17
Rn15_7 i15_Y s749_12 20.5768
Rn15_8 s749_12 buf_A 9.8357
Rn15_9 s749_12 i16_A 10.4027
Cg14 i16_A 0 5.238740e-17
Cg15 buf_A 0 3.041350e-17
Cg16 i15_Y 0 1.020050e-16
Cg17 s749_12 0 1.848060e-16
Cx2 i16_A 0 1.003250e-16
Cx3 buf_A 0 5.330050e-17
Cc12 s749_12 nand_B 1.481890e-16
Cc13 s749_12 s774_10 5.589410e-17
Rn16_10 i16_Y i17_A 19.4973
Cg18 i17_A 0 3.355400e-17
Cg19 i16_Y 0 3.355400e-17
Cx4 i17_A 0 9.572150e-17
Rn17_11 i17_Y i18_A 19.4973
Cg20 i18_A 0 3.355400e-17
Cg21 i17_Y 0 3.355400e-17
Cx5 i18_A 0 9.572150e-17
Rn18_12 i18_Y i19_A 19.4973
Cg22 i19_A 0 3.355400e-17
Cg23 i18_Y 0 3.355400e-17
Cx6 i19_A 0 9.572150e-17
Rn19_13 i19_Y i20_A 19.4973
Cg24 i20_A 0 3.355400e-17
Cg25 i19_Y 0 3.355400e-17
Cx7 i20_A 0 9.572150e-17
Rn2_14 i2_Y i3_A 19.4973
Cg26 i3_A 0 3.269130e-17
Cg27 i2_Y 0 3.269130e-17
Cx8 i3_A 0 5.337830e-17
Rn20_15 i20_Y i21_A 19.4973
Cg28 i21_A 0 3.355400e-17
Cg29 i20_Y 0 3.355400e-17
Cx9 i21_A 0 9.572150e-17
Rn21_16 i21_Y i22_A 19.4973
Cg30 i22_A 0 2.706440e-17
Cg31 i21_Y 0 2.706440e-17
Cc14 i22_A i23_A 1.673050e-17
Cx10 i22_A 0 9.572150e-17
Rn22_17 i22_Y i23_A 30.2652
Cg32 i23_A 0 1.852710e-16
Cg33 i22_Y 0 1.852710e-16
Cc15 i23_A i24_A 2.808530e-17
Cx11 i23_A 0 1.951990e-17
Rn23_18 i23_Y i24_A 20.8277
Cg34 i24_A 0 8.451940e-17
Cg35 i23_Y 0 8.451940e-17
Cc16 i24_A i25_A 2.629080e-17
Cc17 i24_A i26_A 0.000000e+00
Cx12 i24_A 0 7.192660e-17
Rn24_19 i24_Y i25_A 21.0643
Cg36 i25_A 0 7.537060e-17
Cg37 i24_Y 0 7.537060e-17
Cc18 i25_A i26_A 2.922120e-17
Cc19 i25_A i27_A 0.000000e+00
Cx13 i25_A 0 1.885860e-16
Rn25_20 i25_Y i26_A 20.8277
Cg38 i26_A 0 9.627370e-17
Cg39 i25_Y 0 9.627370e-17
Cc20 i26_A i27_A 3.000530e-17
Cc21 i26_A i28_A 0.000000e+00
Cx14 i26_A 0 2.592930e-17
Rn26_21 i26_Y i27_A 21.1313
Cg40 i27_A 0 7.745380e-17
Cg41 i26_Y 0 7.745380e-17
Cc22 i27_A i28_A 3.028690e-17
Cc23 i27_A i29_A 0.000000e+00
Cx15 i27_A 0 1.450400e-16
Rn27_22 i27_Y i28_A 21.3813
Cg42 i28_A 0 1.310300e-16
Cg43 i27_Y 0 1.310300e-16
Cc24 i28_A i29_A 3.028690e-17
Cc25 i28_A i30_A 0.000000e+00
Cx16 i28_A 0 2.417650e-17
Rn28_23 i28_Y i29_A 21.1313
Cg44 i29_A 0 7.738800e-17
Cg45 i28_Y 0 7.738800e-17
Cc26 i29_A i30_A 3.028690e-17
Cx17 i29_A 0 1.450400e-16
Rn29_24 i29_Y i30_A 21.3813
Cg46 i30_A 0 1.351730e-16
Cg47 i29_Y 0 1.351730e-16
Cc27 i30_A nand_B 2.559870e-17
Cx18 i30_A 0 3.774850e-17
Rn3_25 i3_Y i4_A 19.4973
Cg48 i4_A 0 3.038620e-17
Cg49 i3_Y 0 3.038620e-17
Cx19 i4_A 0 9.572150e-17
Rn30_26 i30_Y nand_B 34.8411
Cg50 nand_B 0 3.266650e-16
Cg51 i30_Y 0 3.266650e-16
Cc28 nand_B s774_10 6.072320e-17
Cx20 nand_B 0 2.401540e-18
Cc29 EN nand_B 2.561940e-16
Rn4_27 i4_Y i5_A 19.4973
Cg52 i5_A 0 3.038620e-17
Cg53 i4_Y 0 3.038620e-17
Cx21 i5_A 0 9.572150e-17
Rn5_28 i5_Y i6_A 19.4973
Cg54 i6_A 0 3.038620e-17
Cg55 i5_Y 0 3.038620e-17
Cx22 i6_A 0 9.572150e-17
Rn6_29 i6_Y i7_A 19.4973
Cg56 i7_A 0 3.038620e-17
Cg57 i6_Y 0 3.038620e-17
Cx23 i7_A 0 9.572150e-17
Rn7_30 i7_Y i8_A 30.2652
Cg58 i8_A 0 1.813470e-16
Cg59 i7_Y 0 1.813470e-16
Cc30 i8_A i9_A 2.808530e-17
Cx24 i8_A 0 7.905360e-17
Rn8_31 i8_Y i9_A 20.8277
Cg60 i9_A 0 1.222650e-16
Cg61 i8_Y 0 1.222650e-16
Cc31 i9_A i10_A 2.629080e-17
Rn9_32 i9_Y i10_A 21.0643
Cg62 i10_A 0 1.324940e-16
Cg63 i9_Y 0 1.324940e-16
Rout_33 buf_X s774_10 37.2911
Rout_34 s774_10 s774_14 27.3750
Rout_35 s774_14 s774_24 48.4217
Cg64 buf_X 0 1.499970e-15
Cg65 s774_24 0 5.801230e-15
Cg66 s774_14 0 6.768870e-15
Cg67 s774_10 0 2.639110e-15
Cx25 s774_10 0 1.788930e-16
Cx26 s774_10 0 1.854270e-16
Cx27 s774_10 0 1.489030e-16
Cx28 s774_10 0 1.513330e-16
Cx29 s774_14 0 0.000000e+00
Cx30 s774_14 0 1.530400e-16
Cx31 s774_14 0 1.281540e-16
Cx32 s774_14 0 5.395380e-16
Cx33 s774_14 0 2.099230e-16
Cx34 s774_24 0 1.151150e-16
Cx35 s774_24 0 1.243420e-16
Cx36 s774_24 0 1.215730e-16
Cx37 s774_24 0 0.000000e+00
Cx38 s774_24 0 0.000000e+00
Cx39 s774_24 0 0.000000e+00
Cx40 s774_24 0 0.000000e+00
Cx41 s774_24 0 1.274460e-16
Cx42 s774_24 0 0.000000e+00
Cx43 s774_24 0 7.602100e-17
Cx44 s774_24 0 1.264390e-16
Cx45 s774_24 0 1.489110e-16
Cx46 s774_24 0 0.000000e+00
Cx47 s774_24 0 8.435880e-16
Cx48 s774_24 0 1.856960e-17
Cx49 s774_24 0 0.000000e+00
Cx50 s774_10 0 0.000000e+00
Cx51 s774_10 0 0.000000e+00
Cx52 s774_14 0 1.149120e-16
Cx53 s774_14 0 1.015450e-16
Cx54 s774_10 0 0.000000e+00
Cx55 s774_14 0 2.098260e-17
Cc32 EN s774_10 0.000000e+00
Cx56 s774_24 0 1.093210e-16
Cx57 s774_14 0 3.808660e-16
Cx58 s774_10 0 0.000000e+00
Cx59 s774_24 0 1.247420e-16

.save v(buf_X)
.tran 1p 140n
.control
run
meas tran tp TRIG v(buf_X) VAL=0.9 RISE=5 TARG v(buf_X) VAL=0.9 RISE=25
let f = 20 / tp
print f
.endc
.end
