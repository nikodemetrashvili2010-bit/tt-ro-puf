* Arm A oscillator 12: distributed RC from SPEF
* auto-generated by gen_rc_decks.py
.lib "/home/claude/w/pdk/sky130A/libs.tech/ngspice/sky130.lib.spice" tt
.include "/home/claude/w/pdk/sky130A/libs.ref/sky130_fd_sc_hd/spice/sky130_fd_sc_hd.spice"
.param SUPPLY=1.8
Vdd VPWR 0 {SUPPLY}
Ven EN 0 PULSE(0 1.8 2n 50p 50p 1 2)

* --- Arm A oscillator 12: nand + 30 inverters + tap buffer ---
Xnand EN nand_B 0 0 VPWR VPWR nand_Y sky130_fd_sc_hd__nand2_1
Xi1 i1_A 0 0 VPWR VPWR i1_Y sky130_fd_sc_hd__inv_1
Xi2 i2_A 0 0 VPWR VPWR i2_Y sky130_fd_sc_hd__inv_1
Xi3 i3_A 0 0 VPWR VPWR i3_Y sky130_fd_sc_hd__inv_1
Xi4 i4_A 0 0 VPWR VPWR i4_Y sky130_fd_sc_hd__inv_1
Xi5 i5_A 0 0 VPWR VPWR i5_Y sky130_fd_sc_hd__inv_1
Xi6 i6_A 0 0 VPWR VPWR i6_Y sky130_fd_sc_hd__inv_1
Xi7 i7_A 0 0 VPWR VPWR i7_Y sky130_fd_sc_hd__inv_1
Xi8 i8_A 0 0 VPWR VPWR i8_Y sky130_fd_sc_hd__inv_1
Xi9 i9_A 0 0 VPWR VPWR i9_Y sky130_fd_sc_hd__inv_1
Xi10 i10_A 0 0 VPWR VPWR i10_Y sky130_fd_sc_hd__inv_1
Xi11 i11_A 0 0 VPWR VPWR i11_Y sky130_fd_sc_hd__inv_1
Xi12 i12_A 0 0 VPWR VPWR i12_Y sky130_fd_sc_hd__inv_1
Xi13 i13_A 0 0 VPWR VPWR i13_Y sky130_fd_sc_hd__inv_1
Xi14 i14_A 0 0 VPWR VPWR i14_Y sky130_fd_sc_hd__inv_1
Xi15 i15_A 0 0 VPWR VPWR i15_Y sky130_fd_sc_hd__inv_1
Xi16 i16_A 0 0 VPWR VPWR i16_Y sky130_fd_sc_hd__inv_1
Xi17 i17_A 0 0 VPWR VPWR i17_Y sky130_fd_sc_hd__inv_1
Xi18 i18_A 0 0 VPWR VPWR i18_Y sky130_fd_sc_hd__inv_1
Xi19 i19_A 0 0 VPWR VPWR i19_Y sky130_fd_sc_hd__inv_1
Xi20 i20_A 0 0 VPWR VPWR i20_Y sky130_fd_sc_hd__inv_1
Xi21 i21_A 0 0 VPWR VPWR i21_Y sky130_fd_sc_hd__inv_1
Xi22 i22_A 0 0 VPWR VPWR i22_Y sky130_fd_sc_hd__inv_1
Xi23 i23_A 0 0 VPWR VPWR i23_Y sky130_fd_sc_hd__inv_1
Xi24 i24_A 0 0 VPWR VPWR i24_Y sky130_fd_sc_hd__inv_1
Xi25 i25_A 0 0 VPWR VPWR i25_Y sky130_fd_sc_hd__inv_1
Xi26 i26_A 0 0 VPWR VPWR i26_Y sky130_fd_sc_hd__inv_1
Xi27 i27_A 0 0 VPWR VPWR i27_Y sky130_fd_sc_hd__inv_1
Xi28 i28_A 0 0 VPWR VPWR i28_Y sky130_fd_sc_hd__inv_1
Xi29 i29_A 0 0 VPWR VPWR i29_Y sky130_fd_sc_hd__inv_1
Xi30 i30_A 0 0 VPWR VPWR i30_Y sky130_fd_sc_hd__inv_1
Xbuf buf_A 0 0 VPWR VPWR buf_X sky130_fd_sc_hd__buf_1

Rn0_0 nand_Y i1_A 20.6670
Cg0 i1_A 0 7.967740e-17
Cg1 nand_Y 0 7.967740e-17
Cc0 i1_A nand_B 2.081740e-17
Cx0 i1_A 0 1.235360e-16
Cx1 i1_A 0 5.604900e-17
Rn1_1 i1_Y i2_A 19.9080
Cg2 i2_A 0 2.380210e-17
Cg3 i1_Y 0 2.380210e-17
Cx2 i2_A 0 7.712790e-17
Cx3 i2_A 0 7.712790e-17
Rn10_2 i10_Y i11_A 29.8098
Cg4 i11_A 0 1.243490e-16
Cg5 i10_Y 0 1.243490e-16
Cc1 i11_A i10_A 1.215730e-16
Cc2 i11_A i7_A 2.354100e-17
Cx4 i11_A 0 3.479200e-17
Cx5 i11_A 0 2.354100e-17
Rn11_3 i11_Y i12_A 24.7696
Cg6 i12_A 0 4.254630e-16
Cg7 i11_Y 0 4.254630e-16
Cc3 i12_A i13_A 2.034020e-17
Cx6 i12_A 0 6.004140e-19
Cx7 i12_A 0 5.089240e-16
Rn12_4 i12_Y i13_A 21.6491
Cg8 i13_A 0 1.134920e-16
Cg9 i12_Y 0 1.134920e-16
Cx8 i13_A 0 2.481790e-16
Rn13_5 i13_Y i14_A 33.8812
Cg10 i14_A 0 3.490960e-16
Cg11 i13_Y 0 3.490960e-16
Cc4 i14_A i15_A 5.136810e-17
Cc5 i14_A i29_A 7.836590e-17
Cc6 i14_A i30_A 7.611090e-17
Cx9 i14_A 0 7.869940e-17
Cx10 i14_A 0 8.424720e-17
Cx11 i14_A 0 5.578200e-17
Cx12 i14_A 0 0.000000e+00
Rn14_6 i14_Y i15_A 23.7027
Cg12 i15_A 0 2.337360e-16
Cg13 i14_Y 0 2.337360e-16
Cc7 i15_A i16_A 1.370100e-17
Cc8 i15_A i17_A 1.167460e-16
Cc9 i15_A i18_A 3.524080e-17
Cc10 i15_A s1293_6 3.827190e-17
Cx13 i15_A 0 2.430980e-16
Rn15_7 i15_Y s1293_6 10.8625
Rn15_8 s1293_6 buf_A 20.4786
Rn15_9 s1293_6 i16_A 10.7509
Cg14 i16_A 0 5.866270e-17
Cg15 buf_A 0 1.051620e-16
Cg16 i15_Y 0 1.270840e-16
Cg17 s1293_6 0 2.909090e-16
Cc11 i16_A i17_A 3.331740e-17
Cc12 s1293_6 i17_A 3.471290e-17
Cx14 buf_A 0 1.281540e-16
Rn16_10 i16_Y i17_A 21.6938
Cg18 i17_A 0 1.651780e-16
Cg19 i16_Y 0 1.651780e-16
Rn17_11 i17_Y i18_A 29.8545
Cg20 i18_A 0 9.459400e-17
Cg21 i17_Y 0 9.459400e-17
Cc13 i18_A s1318_26 2.808530e-17
Cx15 i18_A 0 9.250140e-18
Cx16 i18_A 0 6.653980e-17
Cx17 i18_A 0 5.745620e-17
Rn18_12 i18_Y i19_A 20.3188
Cg22 i19_A 0 7.545830e-17
Cg23 i18_Y 0 7.545830e-17
Cc14 i19_A s1318_26 1.773660e-16
Rn19_13 i19_Y i20_A 19.9080
Cg24 i20_A 0 5.407820e-17
Cg25 i19_Y 0 5.407820e-17
Cc15 i20_A s1318_26 1.361430e-16
Rn2_14 i2_Y i3_A 19.9080
Cg26 i3_A 0 2.209030e-17
Cg27 i2_Y 0 2.209030e-17
Cx18 i3_A 0 7.781010e-17
Cx19 i3_A 0 7.781010e-17
Rn20_15 i20_Y i21_A 19.9080
Cg28 i21_A 0 4.429440e-17
Cg29 i20_Y 0 4.429440e-17
Cc16 i21_A s1318_26 1.395340e-16
Rn21_16 i21_Y i22_A 30.5688
Cg30 i22_A 0 1.758110e-16
Cg31 i21_Y 0 1.758110e-16
Cx20 i22_A 0 7.146140e-17
Cc17 i22_A s1318_26 1.066180e-17
Cx21 i22_A 0 0.000000e+00
Cx22 i22_A 0 0.000000e+00
Rn22_17 i22_Y i23_A 19.4973
Cg32 i23_A 0 3.388520e-17
Cg33 i22_Y 0 3.388520e-17
Cx23 i23_A 0 9.556190e-17
Rn23_18 i23_Y i24_A 30.9795
Cg34 i24_A 0 1.945710e-16
Cg35 i23_Y 0 1.945710e-16
Cx24 i24_A 0 6.031910e-17
Cc18 i24_A i25_A 2.808530e-17
Cc19 i24_A s1318_26 3.000230e-17
Cx25 i24_A 0 0.000000e+00
Cx26 i24_A 0 7.602100e-17
Rn24_19 i24_Y i25_A 22.0598
Cg36 i25_A 0 1.549850e-16
Cg37 i24_Y 0 1.549850e-16
Cc20 i25_A s1318_26 2.190150e-16
Rn25_20 i25_Y i26_A 29.8098
Cg38 i26_A 0 1.103070e-16
Cg39 i25_Y 0 1.103070e-16
Cc21 i26_A i27_A 2.524000e-17
Cc22 i26_A s1318_26 3.331740e-17
Cx27 i26_A 0 1.145480e-17
Cx28 i26_A 0 1.240100e-16
Rn26_21 i26_Y i27_A 21.1268
Cg40 i27_A 0 9.589830e-17
Cg41 i26_Y 0 9.589830e-17
Cc23 i27_A i28_A 6.051400e-17
Cx29 i27_A 0 5.733680e-17
Rn27_22 i27_Y i28_A 21.2518
Cg42 i28_A 0 1.002250e-16
Cg43 i27_Y 0 1.002250e-16
Cc24 i28_A i29_A 4.187990e-17
Cx30 i28_A 0 4.203170e-17
Rn28_23 i28_Y i29_A 30.9348
Cg44 i29_A 0 2.258370e-16
Cg45 i28_Y 0 2.258370e-16
Cc25 i29_A i30_A 1.145480e-17
Cx31 i29_A 0 7.599960e-18
Cx32 i29_A 0 2.524000e-17
Cx33 i29_A 0 0.000000e+00
Cx34 i29_A 0 0.000000e+00
Rn29_24 i29_Y i30_A 21.5420
Cg46 i30_A 0 1.170020e-16
Cg47 i29_Y 0 1.170020e-16
Cx35 i30_A 0 1.436910e-16
Rn3_25 i3_Y i4_A 21.2830
Cg48 i4_A 0 8.009950e-17
Cg49 i3_Y 0 8.009950e-17
Cx36 i4_A 0 2.354100e-17
Cx37 i4_A 0 8.221350e-17
Cx38 i4_A 0 1.919220e-16
Rn30_26 i30_Y nand_B 33.8232
Cg50 nand_B 0 3.000460e-16
Cg51 i30_Y 0 3.000460e-16
Cx39 nand_B 0 1.955550e-16
Cx40 nand_B 0 2.147570e-17
Cx41 nand_B 0 1.914030e-16
Cx42 nand_B 0 1.150510e-16
Cx43 nand_B 0 1.143510e-16
Rn4_27 i4_Y i5_A 31.5866
Cg52 i5_A 0 1.629880e-16
Cg53 i4_Y 0 1.629880e-16
Cc26 i5_A i10_A 0.000000e+00
Cx44 i5_A 0 2.720010e-17
Cx45 i5_A 0 2.592350e-17
Cx46 i5_A 0 1.761350e-17
Cx47 i5_A 0 8.915340e-17
Cx48 i5_A 0 7.189820e-17
Cx49 i5_A 0 7.861120e-17
Rn5_28 i5_Y i6_A 19.9080
Cg54 i6_A 0 2.114840e-17
Cg55 i5_Y 0 2.114840e-17
Cx50 i6_A 0 5.552740e-17
Cx51 i6_A 0 1.395340e-16
Rn6_29 i6_Y i7_A 21.1536
Cg56 i7_A 0 7.217670e-17
Cg57 i6_Y 0 7.217670e-17
Cc27 i7_A i9_A 6.746050e-18
Cx52 i7_A 0 1.221360e-16
Cx53 i7_A 0 9.997280e-17
Rn7_30 i7_Y i8_A 19.4973
Cg58 i8_A 0 1.375620e-17
Cg59 i7_Y 0 1.375620e-17
Cc28 i8_A i9_A 7.381510e-17
Cx54 i8_A 0 8.717610e-18
Cx55 i8_A 0 5.337830e-17
Rn8_31 i8_Y i9_A 32.8991
Cg60 i9_A 0 2.597980e-16
Cg61 i8_Y 0 2.597980e-16
Cc29 i9_A i10_A 4.309760e-17
Cx56 i9_A 0 0.000000e+00
Cx57 i9_A 0 8.440430e-17
Cx58 i9_A 0 1.139090e-16
Cx59 i9_A 0 1.951990e-17
Rn9_32 i9_Y i10_A 32.6491
Cg62 i10_A 0 2.903850e-16
Cg63 i9_Y 0 2.903850e-16
Cx60 i10_A 0 0.000000e+00
Cx61 i10_A 0 6.712950e-17
Cx62 i10_A 0 3.850670e-17
Rout_33 buf_X s1318_26 49.4429
Cg64 buf_X 0 1.865000e-15
Cg65 s1318_26 0 1.915930e-15
Cx63 s1318_26 0 2.808530e-17
Cx64 s1318_26 0 8.127390e-17
Cx65 s1318_26 0 3.113580e-17
Cx66 s1318_26 0 1.883000e-16
Cx67 s1318_26 0 1.377430e-17
Cx68 s1318_26 0 1.020940e-16
Cx69 s1318_26 0 7.712790e-17
Cx70 s1318_26 0 4.884020e-17
Cx71 s1318_26 0 2.849410e-16
Cx72 s1318_26 0 1.361610e-17
Cx73 s1318_26 0 4.164950e-17
Cx74 s1318_26 0 1.269740e-17
Cx75 s1318_26 0 1.370560e-15
Cx76 s1318_26 0 3.996140e-18

.save v(buf_X)
.tran 1p 140n
.control
run
meas tran tp TRIG v(buf_X) VAL=0.9 RISE=5 TARG v(buf_X) VAL=0.9 RISE=25
let f = 20 / tp
print f
.endc
.end
