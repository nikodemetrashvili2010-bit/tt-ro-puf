* Arm B per-instance integration, hardware item 8
* auto-generated by gen_instance_decks.py
* control c_, reference r_, and the 16 real instances k00_ to k15_
.lib "/home/pc/pdks/sky130A/libs.tech/ngspice/sky130.lib.spice" ff
.include "/home/pc/pdks/sky130A/libs.ref/sky130_fd_sc_hd/spice/sky130_fd_sc_hd.spice"
.temp -40
.param SUPPLY=1.95
Vdd VPWR 0 {SUPPLY}
Vone ONE 0 1.95
Ven EN 0 PULSE(0 1.95 2n 50p 50p 1 2)

* --- control: macro topology, no capacitance at all ---
Xc_dlyin EN 0 0 VPWR VPWR c_net1 sky130_fd_sc_hd__clkdlybuf4s25_1
Xc_nand c_net1 c_n30 0 0 VPWR VPWR c_n0 sky130_fd_sc_hd__nand2_1
Xc_inv1 c_n0 0 0 VPWR VPWR c_n1 sky130_fd_sc_hd__inv_1
Xc_inv2 c_n1 0 0 VPWR VPWR c_n2 sky130_fd_sc_hd__inv_1
Xc_inv3 c_n2 0 0 VPWR VPWR c_n3 sky130_fd_sc_hd__inv_1
Xc_inv4 c_n3 0 0 VPWR VPWR c_n4 sky130_fd_sc_hd__inv_1
Xc_inv5 c_n4 0 0 VPWR VPWR c_n5 sky130_fd_sc_hd__inv_1
Xc_inv6 c_n5 0 0 VPWR VPWR c_n6 sky130_fd_sc_hd__inv_1
Xc_inv7 c_n6 0 0 VPWR VPWR c_n7 sky130_fd_sc_hd__inv_1
Xc_inv8 c_n7 0 0 VPWR VPWR c_n8 sky130_fd_sc_hd__inv_1
Xc_inv9 c_n8 0 0 VPWR VPWR c_n9 sky130_fd_sc_hd__inv_1
Xc_inv10 c_n9 0 0 VPWR VPWR c_n10 sky130_fd_sc_hd__inv_1
Xc_inv11 c_n10 0 0 VPWR VPWR c_n11 sky130_fd_sc_hd__inv_1
Xc_inv12 c_n11 0 0 VPWR VPWR c_n12 sky130_fd_sc_hd__inv_1
Xc_inv13 c_n12 0 0 VPWR VPWR c_n13 sky130_fd_sc_hd__inv_1
Xc_inv14 c_n13 0 0 VPWR VPWR c_n14 sky130_fd_sc_hd__inv_1
Xc_inv15 c_n14 0 0 VPWR VPWR c_n15 sky130_fd_sc_hd__inv_1
Xc_inv16 c_n15 0 0 VPWR VPWR c_n16 sky130_fd_sc_hd__inv_1
Xc_inv17 c_n16 0 0 VPWR VPWR c_n17 sky130_fd_sc_hd__inv_1
Xc_inv18 c_n17 0 0 VPWR VPWR c_n18 sky130_fd_sc_hd__inv_1
Xc_inv19 c_n18 0 0 VPWR VPWR c_n19 sky130_fd_sc_hd__inv_1
Xc_inv20 c_n19 0 0 VPWR VPWR c_n20 sky130_fd_sc_hd__inv_1
Xc_inv21 c_n20 0 0 VPWR VPWR c_n21 sky130_fd_sc_hd__inv_1
Xc_inv22 c_n21 0 0 VPWR VPWR c_n22 sky130_fd_sc_hd__inv_1
Xc_inv23 c_n22 0 0 VPWR VPWR c_n23 sky130_fd_sc_hd__inv_1
Xc_inv24 c_n23 0 0 VPWR VPWR c_n24 sky130_fd_sc_hd__inv_1
Xc_inv25 c_n24 0 0 VPWR VPWR c_n25 sky130_fd_sc_hd__inv_1
Xc_inv26 c_n25 0 0 VPWR VPWR c_n26 sky130_fd_sc_hd__inv_1
Xc_inv27 c_n26 0 0 VPWR VPWR c_n27 sky130_fd_sc_hd__inv_1
Xc_inv28 c_n27 0 0 VPWR VPWR c_n28 sky130_fd_sc_hd__inv_1
Xc_inv29 c_n28 0 0 VPWR VPWR c_n29 sky130_fd_sc_hd__inv_1
Xc_inv30 c_n29 0 0 VPWR VPWR c_n30 sky130_fd_sc_hd__inv_1
Xc_buf c_n15 0 0 VPWR VPWR c_net2 sky130_fd_sc_hd__buf_1
Xc_dlyout c_net2 0 0 VPWR VPWR c_out sky130_fd_sc_hd__clkdlybuf4s25_1

* --- reference: macro internal extraction only, nothing external ---
Xr_dlyin EN 0 0 VPWR VPWR r_net1 sky130_fd_sc_hd__clkdlybuf4s25_1
Xr_nand r_net1 r_n30 0 0 VPWR VPWR r_n0 sky130_fd_sc_hd__nand2_1
Xr_inv1 r_n0 0 0 VPWR VPWR r_n1 sky130_fd_sc_hd__inv_1
Xr_inv2 r_n1 0 0 VPWR VPWR r_n2 sky130_fd_sc_hd__inv_1
Xr_inv3 r_n2 0 0 VPWR VPWR r_n3 sky130_fd_sc_hd__inv_1
Xr_inv4 r_n3 0 0 VPWR VPWR r_n4 sky130_fd_sc_hd__inv_1
Xr_inv5 r_n4 0 0 VPWR VPWR r_n5 sky130_fd_sc_hd__inv_1
Xr_inv6 r_n5 0 0 VPWR VPWR r_n6 sky130_fd_sc_hd__inv_1
Xr_inv7 r_n6 0 0 VPWR VPWR r_n7 sky130_fd_sc_hd__inv_1
Xr_inv8 r_n7 0 0 VPWR VPWR r_n8 sky130_fd_sc_hd__inv_1
Xr_inv9 r_n8 0 0 VPWR VPWR r_n9 sky130_fd_sc_hd__inv_1
Xr_inv10 r_n9 0 0 VPWR VPWR r_n10 sky130_fd_sc_hd__inv_1
Xr_inv11 r_n10 0 0 VPWR VPWR r_n11 sky130_fd_sc_hd__inv_1
Xr_inv12 r_n11 0 0 VPWR VPWR r_n12 sky130_fd_sc_hd__inv_1
Xr_inv13 r_n12 0 0 VPWR VPWR r_n13 sky130_fd_sc_hd__inv_1
Xr_inv14 r_n13 0 0 VPWR VPWR r_n14 sky130_fd_sc_hd__inv_1
Xr_inv15 r_n14 0 0 VPWR VPWR r_n15 sky130_fd_sc_hd__inv_1
Xr_inv16 r_n15 0 0 VPWR VPWR r_n16 sky130_fd_sc_hd__inv_1
Xr_inv17 r_n16 0 0 VPWR VPWR r_n17 sky130_fd_sc_hd__inv_1
Xr_inv18 r_n17 0 0 VPWR VPWR r_n18 sky130_fd_sc_hd__inv_1
Xr_inv19 r_n18 0 0 VPWR VPWR r_n19 sky130_fd_sc_hd__inv_1
Xr_inv20 r_n19 0 0 VPWR VPWR r_n20 sky130_fd_sc_hd__inv_1
Xr_inv21 r_n20 0 0 VPWR VPWR r_n21 sky130_fd_sc_hd__inv_1
Xr_inv22 r_n21 0 0 VPWR VPWR r_n22 sky130_fd_sc_hd__inv_1
Xr_inv23 r_n22 0 0 VPWR VPWR r_n23 sky130_fd_sc_hd__inv_1
Xr_inv24 r_n23 0 0 VPWR VPWR r_n24 sky130_fd_sc_hd__inv_1
Xr_inv25 r_n24 0 0 VPWR VPWR r_n25 sky130_fd_sc_hd__inv_1
Xr_inv26 r_n25 0 0 VPWR VPWR r_n26 sky130_fd_sc_hd__inv_1
Xr_inv27 r_n26 0 0 VPWR VPWR r_n27 sky130_fd_sc_hd__inv_1
Xr_inv28 r_n27 0 0 VPWR VPWR r_n28 sky130_fd_sc_hd__inv_1
Xr_inv29 r_n28 0 0 VPWR VPWR r_n29 sky130_fd_sc_hd__inv_1
Xr_inv30 r_n29 0 0 VPWR VPWR r_n30 sky130_fd_sc_hd__inv_1
Xr_buf r_n15 0 0 VPWR VPWR r_net2 sky130_fd_sc_hd__buf_1
Xr_dlyout r_net2 0 0 VPWR VPWR r_out sky130_fd_sc_hd__clkdlybuf4s25_1
Cr_n0 r_n0 0 3.068490e-16
Cr_n1 r_n1 0 2.255910e-16
Cr_n2 r_n2 0 1.067930e-16
Cr_n3 r_n3 0 6.592350e-16
Cr_n4 r_n4 0 4.933900e-16
Cr_n5 r_n5 0 2.255700e-16
Cr_n6 r_n6 0 5.757220e-16
Cr_n7 r_n7 0 5.002390e-16
Cr_n8 r_n8 0 1.628300e-16
Cr_n9 r_n9 0 3.187680e-16
Cr_n10 r_n10 0 1.067930e-16
Cr_n11 r_n11 0 1.067930e-16
Cr_n12 r_n12 0 1.233470e-16
Cr_n13 r_n13 0 1.067930e-16
Cr_n14 r_n14 0 1.231760e-16
Cr_n15 r_n15 0 5.925330e-16
Cr_n16 r_n16 0 2.188230e-16
Cr_n17 r_n17 0 5.031700e-16
Cr_n18 r_n18 0 7.865940e-16
Cr_n19 r_n19 0 6.291400e-16
Cr_n20 r_n20 0 1.820890e-16
Cr_n21 r_n21 0 4.232880e-16
Cr_n22 r_n22 0 1.178430e-16
Cr_n23 r_n23 0 1.629830e-16
Cr_n24 r_n24 0 8.774660e-16
Cr_n25 r_n25 0 1.574940e-16
Cr_n26 r_n26 0 7.696420e-16
Cr_n27 r_n27 0 4.887020e-16
Cr_n28 r_n28 0 2.381970e-16
Cr_n29 r_n29 0 1.081190e-16
Cr_n30 r_n30 0 6.156450e-16
Cr_net1 r_net1 0 5.083940e-16
Cr_net2 r_net2 0 7.365850e-16
Cr_en EN 0 1.128140e-15
Cr_out r_out 0 1.942570e-15

* --- instance 0: u_rob0, enable from _323_.X, output into _468_.A1 ---
Xk00_drv EN ONE ONE 0 0 VPWR VPWR k00_edrv sky130_fd_sc_hd__and3_2
Rk00_e0 k00_edrv k00_epin 40.3194
Ck00_eg0 k00_epin 0 2.906930e-15
Ck00_eg1 k00_edrv 0 2.906930e-15
Ck00_ex0 k00_epin 0 3.598350e-16
Ck00_ex1 k00_epin 0 2.146580e-17
Ck00_ex2 k00_epin 0 6.800270e-17
Ck00_ex3 k00_epin 0 1.866590e-16
Xk00_dlyin k00_epin 0 0 VPWR VPWR k00_net1 sky130_fd_sc_hd__clkdlybuf4s25_1
Xk00_nand k00_net1 k00_n30 0 0 VPWR VPWR k00_n0 sky130_fd_sc_hd__nand2_1
Xk00_inv1 k00_n0 0 0 VPWR VPWR k00_n1 sky130_fd_sc_hd__inv_1
Xk00_inv2 k00_n1 0 0 VPWR VPWR k00_n2 sky130_fd_sc_hd__inv_1
Xk00_inv3 k00_n2 0 0 VPWR VPWR k00_n3 sky130_fd_sc_hd__inv_1
Xk00_inv4 k00_n3 0 0 VPWR VPWR k00_n4 sky130_fd_sc_hd__inv_1
Xk00_inv5 k00_n4 0 0 VPWR VPWR k00_n5 sky130_fd_sc_hd__inv_1
Xk00_inv6 k00_n5 0 0 VPWR VPWR k00_n6 sky130_fd_sc_hd__inv_1
Xk00_inv7 k00_n6 0 0 VPWR VPWR k00_n7 sky130_fd_sc_hd__inv_1
Xk00_inv8 k00_n7 0 0 VPWR VPWR k00_n8 sky130_fd_sc_hd__inv_1
Xk00_inv9 k00_n8 0 0 VPWR VPWR k00_n9 sky130_fd_sc_hd__inv_1
Xk00_inv10 k00_n9 0 0 VPWR VPWR k00_n10 sky130_fd_sc_hd__inv_1
Xk00_inv11 k00_n10 0 0 VPWR VPWR k00_n11 sky130_fd_sc_hd__inv_1
Xk00_inv12 k00_n11 0 0 VPWR VPWR k00_n12 sky130_fd_sc_hd__inv_1
Xk00_inv13 k00_n12 0 0 VPWR VPWR k00_n13 sky130_fd_sc_hd__inv_1
Xk00_inv14 k00_n13 0 0 VPWR VPWR k00_n14 sky130_fd_sc_hd__inv_1
Xk00_inv15 k00_n14 0 0 VPWR VPWR k00_n15 sky130_fd_sc_hd__inv_1
Xk00_inv16 k00_n15 0 0 VPWR VPWR k00_n16 sky130_fd_sc_hd__inv_1
Xk00_inv17 k00_n16 0 0 VPWR VPWR k00_n17 sky130_fd_sc_hd__inv_1
Xk00_inv18 k00_n17 0 0 VPWR VPWR k00_n18 sky130_fd_sc_hd__inv_1
Xk00_inv19 k00_n18 0 0 VPWR VPWR k00_n19 sky130_fd_sc_hd__inv_1
Xk00_inv20 k00_n19 0 0 VPWR VPWR k00_n20 sky130_fd_sc_hd__inv_1
Xk00_inv21 k00_n20 0 0 VPWR VPWR k00_n21 sky130_fd_sc_hd__inv_1
Xk00_inv22 k00_n21 0 0 VPWR VPWR k00_n22 sky130_fd_sc_hd__inv_1
Xk00_inv23 k00_n22 0 0 VPWR VPWR k00_n23 sky130_fd_sc_hd__inv_1
Xk00_inv24 k00_n23 0 0 VPWR VPWR k00_n24 sky130_fd_sc_hd__inv_1
Xk00_inv25 k00_n24 0 0 VPWR VPWR k00_n25 sky130_fd_sc_hd__inv_1
Xk00_inv26 k00_n25 0 0 VPWR VPWR k00_n26 sky130_fd_sc_hd__inv_1
Xk00_inv27 k00_n26 0 0 VPWR VPWR k00_n27 sky130_fd_sc_hd__inv_1
Xk00_inv28 k00_n27 0 0 VPWR VPWR k00_n28 sky130_fd_sc_hd__inv_1
Xk00_inv29 k00_n28 0 0 VPWR VPWR k00_n29 sky130_fd_sc_hd__inv_1
Xk00_inv30 k00_n29 0 0 VPWR VPWR k00_n30 sky130_fd_sc_hd__inv_1
Xk00_buf k00_n15 0 0 VPWR VPWR k00_net2 sky130_fd_sc_hd__buf_1
Xk00_dlyout k00_net2 0 0 VPWR VPWR k00_omac sky130_fd_sc_hd__clkdlybuf4s25_1
Ck00_n0 k00_n0 0 3.068490e-16
Ck00_n1 k00_n1 0 2.255910e-16
Ck00_n2 k00_n2 0 1.067930e-16
Ck00_n3 k00_n3 0 6.592350e-16
Ck00_n4 k00_n4 0 4.933900e-16
Ck00_n5 k00_n5 0 2.255700e-16
Ck00_n6 k00_n6 0 5.757220e-16
Ck00_n7 k00_n7 0 5.002390e-16
Ck00_n8 k00_n8 0 1.628300e-16
Ck00_n9 k00_n9 0 3.187680e-16
Ck00_n10 k00_n10 0 1.067930e-16
Ck00_n11 k00_n11 0 1.067930e-16
Ck00_n12 k00_n12 0 1.233470e-16
Ck00_n13 k00_n13 0 1.067930e-16
Ck00_n14 k00_n14 0 1.231760e-16
Ck00_n15 k00_n15 0 5.925330e-16
Ck00_n16 k00_n16 0 2.188230e-16
Ck00_n17 k00_n17 0 5.031700e-16
Ck00_n18 k00_n18 0 7.865940e-16
Ck00_n19 k00_n19 0 6.291400e-16
Ck00_n20 k00_n20 0 1.820890e-16
Ck00_n21 k00_n21 0 4.232880e-16
Ck00_n22 k00_n22 0 1.178430e-16
Ck00_n23 k00_n23 0 1.629830e-16
Ck00_n24 k00_n24 0 8.774660e-16
Ck00_n25 k00_n25 0 1.574940e-16
Ck00_n26 k00_n26 0 7.696420e-16
Ck00_n27 k00_n27 0 4.887020e-16
Ck00_n28 k00_n28 0 2.381970e-16
Ck00_n29 k00_n29 0 1.081190e-16
Ck00_n30 k00_n30 0 6.156450e-16
Ck00_net1 k00_net1 0 5.083940e-16
Ck00_net2 k00_net2 0 7.365850e-16
Ck00_en k00_epin 0 1.128140e-15
Ck00_out k00_omac 0 1.942570e-15
Rk00_o0 k00_omac k00_o329_7 5.0000
Rk00_o1 k00_o329_7 k00_o329_9 141.8210
Rk00_o2 k00_o329_9 k00_orx 21.1571
Ck00_og0 k00_orx 0 1.880730e-16
Ck00_og1 k00_omac 0 2.901330e-17
Ck00_og2 k00_o329_9 0 6.371810e-15
Ck00_og3 k00_o329_7 0 6.212750e-15
Ck00_ox0 k00_o329_9 0 5.677790e-15
Ck00_ox1 k00_o329_9 0 5.074650e-16
Xk00_rcv k00_orx ONE 0 0 0 0 0 VPWR VPWR k00_rxout sky130_fd_sc_hd__a221o_2
Ck00_rxout k00_rxout 0 2.708600e-14

* --- instance 1: u_rob1, enable from _324_.X, output into _467_.A1 ---
Xk01_drv EN ONE ONE 0 0 VPWR VPWR k01_edrv sky130_fd_sc_hd__and3_2
Rk01_e0 k01_edrv k01_epin 36.8521
Ck01_eg0 k01_epin 0 2.741940e-15
Ck01_eg1 k01_edrv 0 2.741940e-15
Ck01_ex0 k01_epin 0 2.114190e-17
Ck01_ex1 k01_epin 0 1.195600e-16
Xk01_dlyin k01_epin 0 0 VPWR VPWR k01_net1 sky130_fd_sc_hd__clkdlybuf4s25_1
Xk01_nand k01_net1 k01_n30 0 0 VPWR VPWR k01_n0 sky130_fd_sc_hd__nand2_1
Xk01_inv1 k01_n0 0 0 VPWR VPWR k01_n1 sky130_fd_sc_hd__inv_1
Xk01_inv2 k01_n1 0 0 VPWR VPWR k01_n2 sky130_fd_sc_hd__inv_1
Xk01_inv3 k01_n2 0 0 VPWR VPWR k01_n3 sky130_fd_sc_hd__inv_1
Xk01_inv4 k01_n3 0 0 VPWR VPWR k01_n4 sky130_fd_sc_hd__inv_1
Xk01_inv5 k01_n4 0 0 VPWR VPWR k01_n5 sky130_fd_sc_hd__inv_1
Xk01_inv6 k01_n5 0 0 VPWR VPWR k01_n6 sky130_fd_sc_hd__inv_1
Xk01_inv7 k01_n6 0 0 VPWR VPWR k01_n7 sky130_fd_sc_hd__inv_1
Xk01_inv8 k01_n7 0 0 VPWR VPWR k01_n8 sky130_fd_sc_hd__inv_1
Xk01_inv9 k01_n8 0 0 VPWR VPWR k01_n9 sky130_fd_sc_hd__inv_1
Xk01_inv10 k01_n9 0 0 VPWR VPWR k01_n10 sky130_fd_sc_hd__inv_1
Xk01_inv11 k01_n10 0 0 VPWR VPWR k01_n11 sky130_fd_sc_hd__inv_1
Xk01_inv12 k01_n11 0 0 VPWR VPWR k01_n12 sky130_fd_sc_hd__inv_1
Xk01_inv13 k01_n12 0 0 VPWR VPWR k01_n13 sky130_fd_sc_hd__inv_1
Xk01_inv14 k01_n13 0 0 VPWR VPWR k01_n14 sky130_fd_sc_hd__inv_1
Xk01_inv15 k01_n14 0 0 VPWR VPWR k01_n15 sky130_fd_sc_hd__inv_1
Xk01_inv16 k01_n15 0 0 VPWR VPWR k01_n16 sky130_fd_sc_hd__inv_1
Xk01_inv17 k01_n16 0 0 VPWR VPWR k01_n17 sky130_fd_sc_hd__inv_1
Xk01_inv18 k01_n17 0 0 VPWR VPWR k01_n18 sky130_fd_sc_hd__inv_1
Xk01_inv19 k01_n18 0 0 VPWR VPWR k01_n19 sky130_fd_sc_hd__inv_1
Xk01_inv20 k01_n19 0 0 VPWR VPWR k01_n20 sky130_fd_sc_hd__inv_1
Xk01_inv21 k01_n20 0 0 VPWR VPWR k01_n21 sky130_fd_sc_hd__inv_1
Xk01_inv22 k01_n21 0 0 VPWR VPWR k01_n22 sky130_fd_sc_hd__inv_1
Xk01_inv23 k01_n22 0 0 VPWR VPWR k01_n23 sky130_fd_sc_hd__inv_1
Xk01_inv24 k01_n23 0 0 VPWR VPWR k01_n24 sky130_fd_sc_hd__inv_1
Xk01_inv25 k01_n24 0 0 VPWR VPWR k01_n25 sky130_fd_sc_hd__inv_1
Xk01_inv26 k01_n25 0 0 VPWR VPWR k01_n26 sky130_fd_sc_hd__inv_1
Xk01_inv27 k01_n26 0 0 VPWR VPWR k01_n27 sky130_fd_sc_hd__inv_1
Xk01_inv28 k01_n27 0 0 VPWR VPWR k01_n28 sky130_fd_sc_hd__inv_1
Xk01_inv29 k01_n28 0 0 VPWR VPWR k01_n29 sky130_fd_sc_hd__inv_1
Xk01_inv30 k01_n29 0 0 VPWR VPWR k01_n30 sky130_fd_sc_hd__inv_1
Xk01_buf k01_n15 0 0 VPWR VPWR k01_net2 sky130_fd_sc_hd__buf_1
Xk01_dlyout k01_net2 0 0 VPWR VPWR k01_omac sky130_fd_sc_hd__clkdlybuf4s25_1
Ck01_n0 k01_n0 0 3.068490e-16
Ck01_n1 k01_n1 0 2.255910e-16
Ck01_n2 k01_n2 0 1.067930e-16
Ck01_n3 k01_n3 0 6.592350e-16
Ck01_n4 k01_n4 0 4.933900e-16
Ck01_n5 k01_n5 0 2.255700e-16
Ck01_n6 k01_n6 0 5.757220e-16
Ck01_n7 k01_n7 0 5.002390e-16
Ck01_n8 k01_n8 0 1.628300e-16
Ck01_n9 k01_n9 0 3.187680e-16
Ck01_n10 k01_n10 0 1.067930e-16
Ck01_n11 k01_n11 0 1.067930e-16
Ck01_n12 k01_n12 0 1.233470e-16
Ck01_n13 k01_n13 0 1.067930e-16
Ck01_n14 k01_n14 0 1.231760e-16
Ck01_n15 k01_n15 0 5.925330e-16
Ck01_n16 k01_n16 0 2.188230e-16
Ck01_n17 k01_n17 0 5.031700e-16
Ck01_n18 k01_n18 0 7.865940e-16
Ck01_n19 k01_n19 0 6.291400e-16
Ck01_n20 k01_n20 0 1.820890e-16
Ck01_n21 k01_n21 0 4.232880e-16
Ck01_n22 k01_n22 0 1.178430e-16
Ck01_n23 k01_n23 0 1.629830e-16
Ck01_n24 k01_n24 0 8.774660e-16
Ck01_n25 k01_n25 0 1.574940e-16
Ck01_n26 k01_n26 0 7.696420e-16
Ck01_n27 k01_n27 0 4.887020e-16
Ck01_n28 k01_n28 0 2.381970e-16
Ck01_n29 k01_n29 0 1.081190e-16
Ck01_n30 k01_n30 0 6.156450e-16
Ck01_net1 k01_net1 0 5.083940e-16
Ck01_net2 k01_net2 0 7.365850e-16
Ck01_en k01_epin 0 1.128140e-15
Ck01_out k01_omac 0 1.942570e-15
Rk01_o0 k01_omac k01_o336_7 5.3036
Rk01_o1 k01_o336_7 k01_o336_9 53.3125
Rk01_o2 k01_o336_9 k01_orx 23.2330
Ck01_og0 k01_orx 0 2.900760e-16
Ck01_og1 k01_omac 0 5.031080e-17
Ck01_og2 k01_o336_9 0 2.040040e-15
Ck01_og3 k01_o336_7 0 1.800270e-15
Ck01_ox0 k01_orx 0 3.086070e-16
Ck01_ox1 k01_orx 0 1.288090e-17
Ck01_ox2 k01_orx 0 3.453710e-17
Ck01_ox3 k01_orx 0 1.730880e-17
Ck01_ox4 k01_o336_9 0 5.677790e-15
Xk01_rcv k01_orx ONE 0 0 0 0 VPWR VPWR k01_rxout sky130_fd_sc_hd__a22o_2
Ck01_rxout k01_rxout 0 5.573040e-15

* --- instance 2: u_rob2, enable from _325_.X, output into _467_.B2 ---
Xk02_drv EN ONE ONE 0 0 VPWR VPWR k02_edrv sky130_fd_sc_hd__and3_2
Rk02_e0 k02_edrv k02_epin 39.0726
Ck02_eg0 k02_epin 0 2.678470e-15
Ck02_eg1 k02_edrv 0 2.678470e-15
Ck02_ex0 k02_epin 0 5.257590e-17
Ck02_ex1 k02_epin 0 3.091650e-16
Ck02_ex2 k02_epin 0 1.306070e-17
Xk02_dlyin k02_epin 0 0 VPWR VPWR k02_net1 sky130_fd_sc_hd__clkdlybuf4s25_1
Xk02_nand k02_net1 k02_n30 0 0 VPWR VPWR k02_n0 sky130_fd_sc_hd__nand2_1
Xk02_inv1 k02_n0 0 0 VPWR VPWR k02_n1 sky130_fd_sc_hd__inv_1
Xk02_inv2 k02_n1 0 0 VPWR VPWR k02_n2 sky130_fd_sc_hd__inv_1
Xk02_inv3 k02_n2 0 0 VPWR VPWR k02_n3 sky130_fd_sc_hd__inv_1
Xk02_inv4 k02_n3 0 0 VPWR VPWR k02_n4 sky130_fd_sc_hd__inv_1
Xk02_inv5 k02_n4 0 0 VPWR VPWR k02_n5 sky130_fd_sc_hd__inv_1
Xk02_inv6 k02_n5 0 0 VPWR VPWR k02_n6 sky130_fd_sc_hd__inv_1
Xk02_inv7 k02_n6 0 0 VPWR VPWR k02_n7 sky130_fd_sc_hd__inv_1
Xk02_inv8 k02_n7 0 0 VPWR VPWR k02_n8 sky130_fd_sc_hd__inv_1
Xk02_inv9 k02_n8 0 0 VPWR VPWR k02_n9 sky130_fd_sc_hd__inv_1
Xk02_inv10 k02_n9 0 0 VPWR VPWR k02_n10 sky130_fd_sc_hd__inv_1
Xk02_inv11 k02_n10 0 0 VPWR VPWR k02_n11 sky130_fd_sc_hd__inv_1
Xk02_inv12 k02_n11 0 0 VPWR VPWR k02_n12 sky130_fd_sc_hd__inv_1
Xk02_inv13 k02_n12 0 0 VPWR VPWR k02_n13 sky130_fd_sc_hd__inv_1
Xk02_inv14 k02_n13 0 0 VPWR VPWR k02_n14 sky130_fd_sc_hd__inv_1
Xk02_inv15 k02_n14 0 0 VPWR VPWR k02_n15 sky130_fd_sc_hd__inv_1
Xk02_inv16 k02_n15 0 0 VPWR VPWR k02_n16 sky130_fd_sc_hd__inv_1
Xk02_inv17 k02_n16 0 0 VPWR VPWR k02_n17 sky130_fd_sc_hd__inv_1
Xk02_inv18 k02_n17 0 0 VPWR VPWR k02_n18 sky130_fd_sc_hd__inv_1
Xk02_inv19 k02_n18 0 0 VPWR VPWR k02_n19 sky130_fd_sc_hd__inv_1
Xk02_inv20 k02_n19 0 0 VPWR VPWR k02_n20 sky130_fd_sc_hd__inv_1
Xk02_inv21 k02_n20 0 0 VPWR VPWR k02_n21 sky130_fd_sc_hd__inv_1
Xk02_inv22 k02_n21 0 0 VPWR VPWR k02_n22 sky130_fd_sc_hd__inv_1
Xk02_inv23 k02_n22 0 0 VPWR VPWR k02_n23 sky130_fd_sc_hd__inv_1
Xk02_inv24 k02_n23 0 0 VPWR VPWR k02_n24 sky130_fd_sc_hd__inv_1
Xk02_inv25 k02_n24 0 0 VPWR VPWR k02_n25 sky130_fd_sc_hd__inv_1
Xk02_inv26 k02_n25 0 0 VPWR VPWR k02_n26 sky130_fd_sc_hd__inv_1
Xk02_inv27 k02_n26 0 0 VPWR VPWR k02_n27 sky130_fd_sc_hd__inv_1
Xk02_inv28 k02_n27 0 0 VPWR VPWR k02_n28 sky130_fd_sc_hd__inv_1
Xk02_inv29 k02_n28 0 0 VPWR VPWR k02_n29 sky130_fd_sc_hd__inv_1
Xk02_inv30 k02_n29 0 0 VPWR VPWR k02_n30 sky130_fd_sc_hd__inv_1
Xk02_buf k02_n15 0 0 VPWR VPWR k02_net2 sky130_fd_sc_hd__buf_1
Xk02_dlyout k02_net2 0 0 VPWR VPWR k02_omac sky130_fd_sc_hd__clkdlybuf4s25_1
Ck02_n0 k02_n0 0 3.068490e-16
Ck02_n1 k02_n1 0 2.255910e-16
Ck02_n2 k02_n2 0 1.067930e-16
Ck02_n3 k02_n3 0 6.592350e-16
Ck02_n4 k02_n4 0 4.933900e-16
Ck02_n5 k02_n5 0 2.255700e-16
Ck02_n6 k02_n6 0 5.757220e-16
Ck02_n7 k02_n7 0 5.002390e-16
Ck02_n8 k02_n8 0 1.628300e-16
Ck02_n9 k02_n9 0 3.187680e-16
Ck02_n10 k02_n10 0 1.067930e-16
Ck02_n11 k02_n11 0 1.067930e-16
Ck02_n12 k02_n12 0 1.233470e-16
Ck02_n13 k02_n13 0 1.067930e-16
Ck02_n14 k02_n14 0 1.231760e-16
Ck02_n15 k02_n15 0 5.925330e-16
Ck02_n16 k02_n16 0 2.188230e-16
Ck02_n17 k02_n17 0 5.031700e-16
Ck02_n18 k02_n18 0 7.865940e-16
Ck02_n19 k02_n19 0 6.291400e-16
Ck02_n20 k02_n20 0 1.820890e-16
Ck02_n21 k02_n21 0 4.232880e-16
Ck02_n22 k02_n22 0 1.178430e-16
Ck02_n23 k02_n23 0 1.629830e-16
Ck02_n24 k02_n24 0 8.774660e-16
Ck02_n25 k02_n25 0 1.574940e-16
Ck02_n26 k02_n26 0 7.696420e-16
Ck02_n27 k02_n27 0 4.887020e-16
Ck02_n28 k02_n28 0 2.381970e-16
Ck02_n29 k02_n29 0 1.081190e-16
Ck02_n30 k02_n30 0 6.156450e-16
Ck02_net1 k02_net1 0 5.083940e-16
Ck02_net2 k02_net2 0 7.365850e-16
Ck02_en k02_epin 0 1.128140e-15
Ck02_out k02_omac 0 1.942570e-15
Rk02_o0 k02_omac k02_orx 22.5679
Ck02_og0 k02_orx 0 4.990480e-16
Ck02_og1 k02_omac 0 4.990480e-16
Ck02_ox0 k02_orx 0 1.371970e-16
Ck02_ox1 k02_orx 0 3.086070e-16
Ck02_ox2 k02_orx 0 7.159990e-17
Xk02_rcv 0 0 ONE k02_orx 0 0 VPWR VPWR k02_rxout sky130_fd_sc_hd__a22o_2
Ck02_rxout k02_rxout 0 5.573040e-15

* --- instance 3: u_rob3, enable from _326_.X, output into _468_.B2 ---
Xk03_drv EN ONE ONE 0 0 VPWR VPWR k03_edrv sky130_fd_sc_hd__and3_2
Rk03_e0 k03_edrv k03_epin 38.6985
Ck03_eg0 k03_epin 0 2.922730e-15
Ck03_eg1 k03_edrv 0 2.922730e-15
Ck03_ex0 k03_epin 0 9.182690e-17
Ck03_ex1 k03_epin 0 8.622900e-18
Ck03_ex2 k03_epin 0 5.522380e-17
Ck03_ex3 k03_epin 0 6.026400e-17
Xk03_dlyin k03_epin 0 0 VPWR VPWR k03_net1 sky130_fd_sc_hd__clkdlybuf4s25_1
Xk03_nand k03_net1 k03_n30 0 0 VPWR VPWR k03_n0 sky130_fd_sc_hd__nand2_1
Xk03_inv1 k03_n0 0 0 VPWR VPWR k03_n1 sky130_fd_sc_hd__inv_1
Xk03_inv2 k03_n1 0 0 VPWR VPWR k03_n2 sky130_fd_sc_hd__inv_1
Xk03_inv3 k03_n2 0 0 VPWR VPWR k03_n3 sky130_fd_sc_hd__inv_1
Xk03_inv4 k03_n3 0 0 VPWR VPWR k03_n4 sky130_fd_sc_hd__inv_1
Xk03_inv5 k03_n4 0 0 VPWR VPWR k03_n5 sky130_fd_sc_hd__inv_1
Xk03_inv6 k03_n5 0 0 VPWR VPWR k03_n6 sky130_fd_sc_hd__inv_1
Xk03_inv7 k03_n6 0 0 VPWR VPWR k03_n7 sky130_fd_sc_hd__inv_1
Xk03_inv8 k03_n7 0 0 VPWR VPWR k03_n8 sky130_fd_sc_hd__inv_1
Xk03_inv9 k03_n8 0 0 VPWR VPWR k03_n9 sky130_fd_sc_hd__inv_1
Xk03_inv10 k03_n9 0 0 VPWR VPWR k03_n10 sky130_fd_sc_hd__inv_1
Xk03_inv11 k03_n10 0 0 VPWR VPWR k03_n11 sky130_fd_sc_hd__inv_1
Xk03_inv12 k03_n11 0 0 VPWR VPWR k03_n12 sky130_fd_sc_hd__inv_1
Xk03_inv13 k03_n12 0 0 VPWR VPWR k03_n13 sky130_fd_sc_hd__inv_1
Xk03_inv14 k03_n13 0 0 VPWR VPWR k03_n14 sky130_fd_sc_hd__inv_1
Xk03_inv15 k03_n14 0 0 VPWR VPWR k03_n15 sky130_fd_sc_hd__inv_1
Xk03_inv16 k03_n15 0 0 VPWR VPWR k03_n16 sky130_fd_sc_hd__inv_1
Xk03_inv17 k03_n16 0 0 VPWR VPWR k03_n17 sky130_fd_sc_hd__inv_1
Xk03_inv18 k03_n17 0 0 VPWR VPWR k03_n18 sky130_fd_sc_hd__inv_1
Xk03_inv19 k03_n18 0 0 VPWR VPWR k03_n19 sky130_fd_sc_hd__inv_1
Xk03_inv20 k03_n19 0 0 VPWR VPWR k03_n20 sky130_fd_sc_hd__inv_1
Xk03_inv21 k03_n20 0 0 VPWR VPWR k03_n21 sky130_fd_sc_hd__inv_1
Xk03_inv22 k03_n21 0 0 VPWR VPWR k03_n22 sky130_fd_sc_hd__inv_1
Xk03_inv23 k03_n22 0 0 VPWR VPWR k03_n23 sky130_fd_sc_hd__inv_1
Xk03_inv24 k03_n23 0 0 VPWR VPWR k03_n24 sky130_fd_sc_hd__inv_1
Xk03_inv25 k03_n24 0 0 VPWR VPWR k03_n25 sky130_fd_sc_hd__inv_1
Xk03_inv26 k03_n25 0 0 VPWR VPWR k03_n26 sky130_fd_sc_hd__inv_1
Xk03_inv27 k03_n26 0 0 VPWR VPWR k03_n27 sky130_fd_sc_hd__inv_1
Xk03_inv28 k03_n27 0 0 VPWR VPWR k03_n28 sky130_fd_sc_hd__inv_1
Xk03_inv29 k03_n28 0 0 VPWR VPWR k03_n29 sky130_fd_sc_hd__inv_1
Xk03_inv30 k03_n29 0 0 VPWR VPWR k03_n30 sky130_fd_sc_hd__inv_1
Xk03_buf k03_n15 0 0 VPWR VPWR k03_net2 sky130_fd_sc_hd__buf_1
Xk03_dlyout k03_net2 0 0 VPWR VPWR k03_omac sky130_fd_sc_hd__clkdlybuf4s25_1
Ck03_n0 k03_n0 0 3.068490e-16
Ck03_n1 k03_n1 0 2.255910e-16
Ck03_n2 k03_n2 0 1.067930e-16
Ck03_n3 k03_n3 0 6.592350e-16
Ck03_n4 k03_n4 0 4.933900e-16
Ck03_n5 k03_n5 0 2.255700e-16
Ck03_n6 k03_n6 0 5.757220e-16
Ck03_n7 k03_n7 0 5.002390e-16
Ck03_n8 k03_n8 0 1.628300e-16
Ck03_n9 k03_n9 0 3.187680e-16
Ck03_n10 k03_n10 0 1.067930e-16
Ck03_n11 k03_n11 0 1.067930e-16
Ck03_n12 k03_n12 0 1.233470e-16
Ck03_n13 k03_n13 0 1.067930e-16
Ck03_n14 k03_n14 0 1.231760e-16
Ck03_n15 k03_n15 0 5.925330e-16
Ck03_n16 k03_n16 0 2.188230e-16
Ck03_n17 k03_n17 0 5.031700e-16
Ck03_n18 k03_n18 0 7.865940e-16
Ck03_n19 k03_n19 0 6.291400e-16
Ck03_n20 k03_n20 0 1.820890e-16
Ck03_n21 k03_n21 0 4.232880e-16
Ck03_n22 k03_n22 0 1.178430e-16
Ck03_n23 k03_n23 0 1.629830e-16
Ck03_n24 k03_n24 0 8.774660e-16
Ck03_n25 k03_n25 0 1.574940e-16
Ck03_n26 k03_n26 0 7.696420e-16
Ck03_n27 k03_n27 0 4.887020e-16
Ck03_n28 k03_n28 0 2.381970e-16
Ck03_n29 k03_n29 0 1.081190e-16
Ck03_n30 k03_n30 0 6.156450e-16
Ck03_net1 k03_net1 0 5.083940e-16
Ck03_net2 k03_net2 0 7.365850e-16
Ck03_en k03_epin 0 1.128140e-15
Ck03_out k03_omac 0 1.942570e-15
Rk03_o0 k03_omac k03_orx 47.5679
Ck03_og0 k03_orx 0 9.826300e-16
Ck03_og1 k03_omac 0 9.826300e-16
Ck03_ox0 k03_orx 0 2.091370e-16
Ck03_ox1 k03_orx 0 8.504020e-16
Ck03_ox2 k03_orx 0 2.746040e-16
Ck03_ox3 k03_orx 0 1.465760e-17
Xk03_rcv 0 0 ONE k03_orx 0 0 0 VPWR VPWR k03_rxout sky130_fd_sc_hd__a221o_2
Ck03_rxout k03_rxout 0 2.708600e-14

* --- instance 4: u_rob4, enable from _327_.X, output into _463_.A1 ---
Xk04_drv EN ONE ONE 0 0 VPWR VPWR k04_edrv sky130_fd_sc_hd__and3_2
Rk04_e0 k04_edrv k04_epin 30.1929
Ck04_eg0 k04_epin 0 5.131880e-16
Ck04_eg1 k04_edrv 0 5.131880e-16
Ck04_ex0 k04_epin 0 1.002620e-16
Xk04_dlyin k04_epin 0 0 VPWR VPWR k04_net1 sky130_fd_sc_hd__clkdlybuf4s25_1
Xk04_nand k04_net1 k04_n30 0 0 VPWR VPWR k04_n0 sky130_fd_sc_hd__nand2_1
Xk04_inv1 k04_n0 0 0 VPWR VPWR k04_n1 sky130_fd_sc_hd__inv_1
Xk04_inv2 k04_n1 0 0 VPWR VPWR k04_n2 sky130_fd_sc_hd__inv_1
Xk04_inv3 k04_n2 0 0 VPWR VPWR k04_n3 sky130_fd_sc_hd__inv_1
Xk04_inv4 k04_n3 0 0 VPWR VPWR k04_n4 sky130_fd_sc_hd__inv_1
Xk04_inv5 k04_n4 0 0 VPWR VPWR k04_n5 sky130_fd_sc_hd__inv_1
Xk04_inv6 k04_n5 0 0 VPWR VPWR k04_n6 sky130_fd_sc_hd__inv_1
Xk04_inv7 k04_n6 0 0 VPWR VPWR k04_n7 sky130_fd_sc_hd__inv_1
Xk04_inv8 k04_n7 0 0 VPWR VPWR k04_n8 sky130_fd_sc_hd__inv_1
Xk04_inv9 k04_n8 0 0 VPWR VPWR k04_n9 sky130_fd_sc_hd__inv_1
Xk04_inv10 k04_n9 0 0 VPWR VPWR k04_n10 sky130_fd_sc_hd__inv_1
Xk04_inv11 k04_n10 0 0 VPWR VPWR k04_n11 sky130_fd_sc_hd__inv_1
Xk04_inv12 k04_n11 0 0 VPWR VPWR k04_n12 sky130_fd_sc_hd__inv_1
Xk04_inv13 k04_n12 0 0 VPWR VPWR k04_n13 sky130_fd_sc_hd__inv_1
Xk04_inv14 k04_n13 0 0 VPWR VPWR k04_n14 sky130_fd_sc_hd__inv_1
Xk04_inv15 k04_n14 0 0 VPWR VPWR k04_n15 sky130_fd_sc_hd__inv_1
Xk04_inv16 k04_n15 0 0 VPWR VPWR k04_n16 sky130_fd_sc_hd__inv_1
Xk04_inv17 k04_n16 0 0 VPWR VPWR k04_n17 sky130_fd_sc_hd__inv_1
Xk04_inv18 k04_n17 0 0 VPWR VPWR k04_n18 sky130_fd_sc_hd__inv_1
Xk04_inv19 k04_n18 0 0 VPWR VPWR k04_n19 sky130_fd_sc_hd__inv_1
Xk04_inv20 k04_n19 0 0 VPWR VPWR k04_n20 sky130_fd_sc_hd__inv_1
Xk04_inv21 k04_n20 0 0 VPWR VPWR k04_n21 sky130_fd_sc_hd__inv_1
Xk04_inv22 k04_n21 0 0 VPWR VPWR k04_n22 sky130_fd_sc_hd__inv_1
Xk04_inv23 k04_n22 0 0 VPWR VPWR k04_n23 sky130_fd_sc_hd__inv_1
Xk04_inv24 k04_n23 0 0 VPWR VPWR k04_n24 sky130_fd_sc_hd__inv_1
Xk04_inv25 k04_n24 0 0 VPWR VPWR k04_n25 sky130_fd_sc_hd__inv_1
Xk04_inv26 k04_n25 0 0 VPWR VPWR k04_n26 sky130_fd_sc_hd__inv_1
Xk04_inv27 k04_n26 0 0 VPWR VPWR k04_n27 sky130_fd_sc_hd__inv_1
Xk04_inv28 k04_n27 0 0 VPWR VPWR k04_n28 sky130_fd_sc_hd__inv_1
Xk04_inv29 k04_n28 0 0 VPWR VPWR k04_n29 sky130_fd_sc_hd__inv_1
Xk04_inv30 k04_n29 0 0 VPWR VPWR k04_n30 sky130_fd_sc_hd__inv_1
Xk04_buf k04_n15 0 0 VPWR VPWR k04_net2 sky130_fd_sc_hd__buf_1
Xk04_dlyout k04_net2 0 0 VPWR VPWR k04_omac sky130_fd_sc_hd__clkdlybuf4s25_1
Ck04_n0 k04_n0 0 3.068490e-16
Ck04_n1 k04_n1 0 2.255910e-16
Ck04_n2 k04_n2 0 1.067930e-16
Ck04_n3 k04_n3 0 6.592350e-16
Ck04_n4 k04_n4 0 4.933900e-16
Ck04_n5 k04_n5 0 2.255700e-16
Ck04_n6 k04_n6 0 5.757220e-16
Ck04_n7 k04_n7 0 5.002390e-16
Ck04_n8 k04_n8 0 1.628300e-16
Ck04_n9 k04_n9 0 3.187680e-16
Ck04_n10 k04_n10 0 1.067930e-16
Ck04_n11 k04_n11 0 1.067930e-16
Ck04_n12 k04_n12 0 1.233470e-16
Ck04_n13 k04_n13 0 1.067930e-16
Ck04_n14 k04_n14 0 1.231760e-16
Ck04_n15 k04_n15 0 5.925330e-16
Ck04_n16 k04_n16 0 2.188230e-16
Ck04_n17 k04_n17 0 5.031700e-16
Ck04_n18 k04_n18 0 7.865940e-16
Ck04_n19 k04_n19 0 6.291400e-16
Ck04_n20 k04_n20 0 1.820890e-16
Ck04_n21 k04_n21 0 4.232880e-16
Ck04_n22 k04_n22 0 1.178430e-16
Ck04_n23 k04_n23 0 1.629830e-16
Ck04_n24 k04_n24 0 8.774660e-16
Ck04_n25 k04_n25 0 1.574940e-16
Ck04_n26 k04_n26 0 7.696420e-16
Ck04_n27 k04_n27 0 4.887020e-16
Ck04_n28 k04_n28 0 2.381970e-16
Ck04_n29 k04_n29 0 1.081190e-16
Ck04_n30 k04_n30 0 6.156450e-16
Ck04_net1 k04_net1 0 5.083940e-16
Ck04_net2 k04_net2 0 7.365850e-16
Ck04_en k04_epin 0 1.128140e-15
Ck04_out k04_omac 0 1.942570e-15
Rk04_o0 k04_omac k04_o339_11 5.9107
Rk04_o1 k04_o339_11 k04_o339_13 154.3480
Rk04_o2 k04_o339_13 k04_o339_33 43.1183
Rk04_o3 k04_o339_33 k04_orx 9.3000
Ck04_og0 k04_omac 0 5.973990e-17
Ck04_og1 k04_o339_33 0 2.106030e-15
Ck04_og2 k04_o339_13 0 1.017640e-14
Ck04_og3 k04_o339_11 0 8.130140e-15
Ck04_ox0 k04_o339_13 0 1.321080e-15
Ck04_ox1 k04_o339_33 0 8.501520e-17
Ck04_ox2 k04_o339_33 0 1.857790e-16
Ck04_ox3 k04_o339_33 0 1.361140e-16
Ck04_ox4 k04_o339_33 0 2.250740e-16
Ck04_ox5 k04_o339_33 0 3.409120e-17
Ck04_ox6 k04_o339_33 0 1.333430e-17
Ck04_ox7 k04_o339_33 0 4.886370e-17
Ck04_ox8 k04_o339_13 0 5.371650e-16
Xk04_rcv k04_orx ONE 0 0 0 0 0 VPWR VPWR k04_rxout sky130_fd_sc_hd__a221o_2
Ck04_rxout k04_rxout 0 1.194940e-14

* --- instance 5: u_rob5, enable from _328_.X, output into _462_.A1 ---
Xk05_drv EN ONE ONE 0 0 VPWR VPWR k05_edrv sky130_fd_sc_hd__and3_2
Rk05_e0 k05_edrv k05_epin 23.2643
Ck05_eg0 k05_epin 0 3.785370e-16
Ck05_eg1 k05_edrv 0 3.785370e-16
Ck05_ex0 k05_epin 0 1.096530e-16
Ck05_ex1 k05_epin 0 1.878870e-16
Ck05_ex2 k05_epin 0 2.269020e-17
Ck05_ex3 k05_epin 0 1.494650e-16
Ck05_ex4 k05_epin 0 1.425750e-16
Ck05_ex5 k05_epin 0 1.878870e-16
Xk05_dlyin k05_epin 0 0 VPWR VPWR k05_net1 sky130_fd_sc_hd__clkdlybuf4s25_1
Xk05_nand k05_net1 k05_n30 0 0 VPWR VPWR k05_n0 sky130_fd_sc_hd__nand2_1
Xk05_inv1 k05_n0 0 0 VPWR VPWR k05_n1 sky130_fd_sc_hd__inv_1
Xk05_inv2 k05_n1 0 0 VPWR VPWR k05_n2 sky130_fd_sc_hd__inv_1
Xk05_inv3 k05_n2 0 0 VPWR VPWR k05_n3 sky130_fd_sc_hd__inv_1
Xk05_inv4 k05_n3 0 0 VPWR VPWR k05_n4 sky130_fd_sc_hd__inv_1
Xk05_inv5 k05_n4 0 0 VPWR VPWR k05_n5 sky130_fd_sc_hd__inv_1
Xk05_inv6 k05_n5 0 0 VPWR VPWR k05_n6 sky130_fd_sc_hd__inv_1
Xk05_inv7 k05_n6 0 0 VPWR VPWR k05_n7 sky130_fd_sc_hd__inv_1
Xk05_inv8 k05_n7 0 0 VPWR VPWR k05_n8 sky130_fd_sc_hd__inv_1
Xk05_inv9 k05_n8 0 0 VPWR VPWR k05_n9 sky130_fd_sc_hd__inv_1
Xk05_inv10 k05_n9 0 0 VPWR VPWR k05_n10 sky130_fd_sc_hd__inv_1
Xk05_inv11 k05_n10 0 0 VPWR VPWR k05_n11 sky130_fd_sc_hd__inv_1
Xk05_inv12 k05_n11 0 0 VPWR VPWR k05_n12 sky130_fd_sc_hd__inv_1
Xk05_inv13 k05_n12 0 0 VPWR VPWR k05_n13 sky130_fd_sc_hd__inv_1
Xk05_inv14 k05_n13 0 0 VPWR VPWR k05_n14 sky130_fd_sc_hd__inv_1
Xk05_inv15 k05_n14 0 0 VPWR VPWR k05_n15 sky130_fd_sc_hd__inv_1
Xk05_inv16 k05_n15 0 0 VPWR VPWR k05_n16 sky130_fd_sc_hd__inv_1
Xk05_inv17 k05_n16 0 0 VPWR VPWR k05_n17 sky130_fd_sc_hd__inv_1
Xk05_inv18 k05_n17 0 0 VPWR VPWR k05_n18 sky130_fd_sc_hd__inv_1
Xk05_inv19 k05_n18 0 0 VPWR VPWR k05_n19 sky130_fd_sc_hd__inv_1
Xk05_inv20 k05_n19 0 0 VPWR VPWR k05_n20 sky130_fd_sc_hd__inv_1
Xk05_inv21 k05_n20 0 0 VPWR VPWR k05_n21 sky130_fd_sc_hd__inv_1
Xk05_inv22 k05_n21 0 0 VPWR VPWR k05_n22 sky130_fd_sc_hd__inv_1
Xk05_inv23 k05_n22 0 0 VPWR VPWR k05_n23 sky130_fd_sc_hd__inv_1
Xk05_inv24 k05_n23 0 0 VPWR VPWR k05_n24 sky130_fd_sc_hd__inv_1
Xk05_inv25 k05_n24 0 0 VPWR VPWR k05_n25 sky130_fd_sc_hd__inv_1
Xk05_inv26 k05_n25 0 0 VPWR VPWR k05_n26 sky130_fd_sc_hd__inv_1
Xk05_inv27 k05_n26 0 0 VPWR VPWR k05_n27 sky130_fd_sc_hd__inv_1
Xk05_inv28 k05_n27 0 0 VPWR VPWR k05_n28 sky130_fd_sc_hd__inv_1
Xk05_inv29 k05_n28 0 0 VPWR VPWR k05_n29 sky130_fd_sc_hd__inv_1
Xk05_inv30 k05_n29 0 0 VPWR VPWR k05_n30 sky130_fd_sc_hd__inv_1
Xk05_buf k05_n15 0 0 VPWR VPWR k05_net2 sky130_fd_sc_hd__buf_1
Xk05_dlyout k05_net2 0 0 VPWR VPWR k05_omac sky130_fd_sc_hd__clkdlybuf4s25_1
Ck05_n0 k05_n0 0 3.068490e-16
Ck05_n1 k05_n1 0 2.255910e-16
Ck05_n2 k05_n2 0 1.067930e-16
Ck05_n3 k05_n3 0 6.592350e-16
Ck05_n4 k05_n4 0 4.933900e-16
Ck05_n5 k05_n5 0 2.255700e-16
Ck05_n6 k05_n6 0 5.757220e-16
Ck05_n7 k05_n7 0 5.002390e-16
Ck05_n8 k05_n8 0 1.628300e-16
Ck05_n9 k05_n9 0 3.187680e-16
Ck05_n10 k05_n10 0 1.067930e-16
Ck05_n11 k05_n11 0 1.067930e-16
Ck05_n12 k05_n12 0 1.233470e-16
Ck05_n13 k05_n13 0 1.067930e-16
Ck05_n14 k05_n14 0 1.231760e-16
Ck05_n15 k05_n15 0 5.925330e-16
Ck05_n16 k05_n16 0 2.188230e-16
Ck05_n17 k05_n17 0 5.031700e-16
Ck05_n18 k05_n18 0 7.865940e-16
Ck05_n19 k05_n19 0 6.291400e-16
Ck05_n20 k05_n20 0 1.820890e-16
Ck05_n21 k05_n21 0 4.232880e-16
Ck05_n22 k05_n22 0 1.178430e-16
Ck05_n23 k05_n23 0 1.629830e-16
Ck05_n24 k05_n24 0 8.774660e-16
Ck05_n25 k05_n25 0 1.574940e-16
Ck05_n26 k05_n26 0 7.696420e-16
Ck05_n27 k05_n27 0 4.887020e-16
Ck05_n28 k05_n28 0 2.381970e-16
Ck05_n29 k05_n29 0 1.081190e-16
Ck05_n30 k05_n30 0 6.156450e-16
Ck05_net1 k05_net1 0 5.083940e-16
Ck05_net2 k05_net2 0 7.365850e-16
Ck05_en k05_epin 0 1.128140e-15
Ck05_out k05_omac 0 1.942570e-15
Rk05_o0 k05_omac k05_orx 48.6229
Ck05_og0 k05_orx 0 4.826520e-15
Ck05_og1 k05_omac 0 4.826520e-15
Ck05_ox0 k05_orx 0 1.302700e-16
Ck05_ox1 k05_orx 0 8.612300e-18
Ck05_ox2 k05_orx 0 3.204440e-15
Ck05_ox3 k05_orx 0 6.354810e-17
Ck05_ox4 k05_orx 0 1.321080e-15
Xk05_rcv k05_orx ONE 0 0 0 0 VPWR VPWR k05_rxout sky130_fd_sc_hd__a22o_2
Ck05_rxout k05_rxout 0 1.769010e-14

* --- instance 6: u_rob6, enable from _329_.X, output into _462_.B2 ---
Xk06_drv EN ONE ONE 0 0 VPWR VPWR k06_edrv sky130_fd_sc_hd__and3_2
Rk06_e0 k06_edrv k06_epin 32.7464
Ck06_eg0 k06_epin 0 4.932330e-16
Ck06_eg1 k06_edrv 0 4.932330e-16
Ck06_ex0 k06_epin 0 3.682550e-18
Ck06_ex1 k06_epin 0 7.159990e-17
Ck06_ex2 k06_epin 0 4.495460e-16
Ck06_ex3 k06_epin 0 2.342040e-17
Ck06_ex4 k06_epin 0 3.186760e-17
Xk06_dlyin k06_epin 0 0 VPWR VPWR k06_net1 sky130_fd_sc_hd__clkdlybuf4s25_1
Xk06_nand k06_net1 k06_n30 0 0 VPWR VPWR k06_n0 sky130_fd_sc_hd__nand2_1
Xk06_inv1 k06_n0 0 0 VPWR VPWR k06_n1 sky130_fd_sc_hd__inv_1
Xk06_inv2 k06_n1 0 0 VPWR VPWR k06_n2 sky130_fd_sc_hd__inv_1
Xk06_inv3 k06_n2 0 0 VPWR VPWR k06_n3 sky130_fd_sc_hd__inv_1
Xk06_inv4 k06_n3 0 0 VPWR VPWR k06_n4 sky130_fd_sc_hd__inv_1
Xk06_inv5 k06_n4 0 0 VPWR VPWR k06_n5 sky130_fd_sc_hd__inv_1
Xk06_inv6 k06_n5 0 0 VPWR VPWR k06_n6 sky130_fd_sc_hd__inv_1
Xk06_inv7 k06_n6 0 0 VPWR VPWR k06_n7 sky130_fd_sc_hd__inv_1
Xk06_inv8 k06_n7 0 0 VPWR VPWR k06_n8 sky130_fd_sc_hd__inv_1
Xk06_inv9 k06_n8 0 0 VPWR VPWR k06_n9 sky130_fd_sc_hd__inv_1
Xk06_inv10 k06_n9 0 0 VPWR VPWR k06_n10 sky130_fd_sc_hd__inv_1
Xk06_inv11 k06_n10 0 0 VPWR VPWR k06_n11 sky130_fd_sc_hd__inv_1
Xk06_inv12 k06_n11 0 0 VPWR VPWR k06_n12 sky130_fd_sc_hd__inv_1
Xk06_inv13 k06_n12 0 0 VPWR VPWR k06_n13 sky130_fd_sc_hd__inv_1
Xk06_inv14 k06_n13 0 0 VPWR VPWR k06_n14 sky130_fd_sc_hd__inv_1
Xk06_inv15 k06_n14 0 0 VPWR VPWR k06_n15 sky130_fd_sc_hd__inv_1
Xk06_inv16 k06_n15 0 0 VPWR VPWR k06_n16 sky130_fd_sc_hd__inv_1
Xk06_inv17 k06_n16 0 0 VPWR VPWR k06_n17 sky130_fd_sc_hd__inv_1
Xk06_inv18 k06_n17 0 0 VPWR VPWR k06_n18 sky130_fd_sc_hd__inv_1
Xk06_inv19 k06_n18 0 0 VPWR VPWR k06_n19 sky130_fd_sc_hd__inv_1
Xk06_inv20 k06_n19 0 0 VPWR VPWR k06_n20 sky130_fd_sc_hd__inv_1
Xk06_inv21 k06_n20 0 0 VPWR VPWR k06_n21 sky130_fd_sc_hd__inv_1
Xk06_inv22 k06_n21 0 0 VPWR VPWR k06_n22 sky130_fd_sc_hd__inv_1
Xk06_inv23 k06_n22 0 0 VPWR VPWR k06_n23 sky130_fd_sc_hd__inv_1
Xk06_inv24 k06_n23 0 0 VPWR VPWR k06_n24 sky130_fd_sc_hd__inv_1
Xk06_inv25 k06_n24 0 0 VPWR VPWR k06_n25 sky130_fd_sc_hd__inv_1
Xk06_inv26 k06_n25 0 0 VPWR VPWR k06_n26 sky130_fd_sc_hd__inv_1
Xk06_inv27 k06_n26 0 0 VPWR VPWR k06_n27 sky130_fd_sc_hd__inv_1
Xk06_inv28 k06_n27 0 0 VPWR VPWR k06_n28 sky130_fd_sc_hd__inv_1
Xk06_inv29 k06_n28 0 0 VPWR VPWR k06_n29 sky130_fd_sc_hd__inv_1
Xk06_inv30 k06_n29 0 0 VPWR VPWR k06_n30 sky130_fd_sc_hd__inv_1
Xk06_buf k06_n15 0 0 VPWR VPWR k06_net2 sky130_fd_sc_hd__buf_1
Xk06_dlyout k06_net2 0 0 VPWR VPWR k06_omac sky130_fd_sc_hd__clkdlybuf4s25_1
Ck06_n0 k06_n0 0 3.068490e-16
Ck06_n1 k06_n1 0 2.255910e-16
Ck06_n2 k06_n2 0 1.067930e-16
Ck06_n3 k06_n3 0 6.592350e-16
Ck06_n4 k06_n4 0 4.933900e-16
Ck06_n5 k06_n5 0 2.255700e-16
Ck06_n6 k06_n6 0 5.757220e-16
Ck06_n7 k06_n7 0 5.002390e-16
Ck06_n8 k06_n8 0 1.628300e-16
Ck06_n9 k06_n9 0 3.187680e-16
Ck06_n10 k06_n10 0 1.067930e-16
Ck06_n11 k06_n11 0 1.067930e-16
Ck06_n12 k06_n12 0 1.233470e-16
Ck06_n13 k06_n13 0 1.067930e-16
Ck06_n14 k06_n14 0 1.231760e-16
Ck06_n15 k06_n15 0 5.925330e-16
Ck06_n16 k06_n16 0 2.188230e-16
Ck06_n17 k06_n17 0 5.031700e-16
Ck06_n18 k06_n18 0 7.865940e-16
Ck06_n19 k06_n19 0 6.291400e-16
Ck06_n20 k06_n20 0 1.820890e-16
Ck06_n21 k06_n21 0 4.232880e-16
Ck06_n22 k06_n22 0 1.178430e-16
Ck06_n23 k06_n23 0 1.629830e-16
Ck06_n24 k06_n24 0 8.774660e-16
Ck06_n25 k06_n25 0 1.574940e-16
Ck06_n26 k06_n26 0 7.696420e-16
Ck06_n27 k06_n27 0 4.887020e-16
Ck06_n28 k06_n28 0 2.381970e-16
Ck06_n29 k06_n29 0 1.081190e-16
Ck06_n30 k06_n30 0 6.156450e-16
Ck06_net1 k06_net1 0 5.083940e-16
Ck06_net2 k06_net2 0 7.365850e-16
Ck06_en k06_epin 0 1.128140e-15
Ck06_out k06_omac 0 1.942570e-15
Rk06_o0 k06_omac k06_orx 38.9080
Ck06_og0 k06_orx 0 2.474690e-15
Ck06_og1 k06_omac 0 2.474690e-15
Ck06_ox0 k06_orx 0 9.190210e-17
Ck06_ox1 k06_orx 0 1.302700e-16
Ck06_ox2 k06_orx 0 3.682550e-18
Xk06_rcv 0 0 ONE k06_orx 0 0 VPWR VPWR k06_rxout sky130_fd_sc_hd__a22o_2
Ck06_rxout k06_rxout 0 1.769010e-14

* --- instance 7: u_rob7, enable from _330_.X, output into _463_.B2 ---
Xk07_drv EN ONE ONE 0 0 VPWR VPWR k07_edrv sky130_fd_sc_hd__and3_2
Rk07_e0 k07_edrv k07_epin 22.3000
Ck07_eg0 k07_epin 0 5.439200e-16
Ck07_eg1 k07_edrv 0 5.439200e-16
Ck07_ex0 k07_epin 0 4.047070e-16
Ck07_ex1 k07_epin 0 3.976570e-17
Xk07_dlyin k07_epin 0 0 VPWR VPWR k07_net1 sky130_fd_sc_hd__clkdlybuf4s25_1
Xk07_nand k07_net1 k07_n30 0 0 VPWR VPWR k07_n0 sky130_fd_sc_hd__nand2_1
Xk07_inv1 k07_n0 0 0 VPWR VPWR k07_n1 sky130_fd_sc_hd__inv_1
Xk07_inv2 k07_n1 0 0 VPWR VPWR k07_n2 sky130_fd_sc_hd__inv_1
Xk07_inv3 k07_n2 0 0 VPWR VPWR k07_n3 sky130_fd_sc_hd__inv_1
Xk07_inv4 k07_n3 0 0 VPWR VPWR k07_n4 sky130_fd_sc_hd__inv_1
Xk07_inv5 k07_n4 0 0 VPWR VPWR k07_n5 sky130_fd_sc_hd__inv_1
Xk07_inv6 k07_n5 0 0 VPWR VPWR k07_n6 sky130_fd_sc_hd__inv_1
Xk07_inv7 k07_n6 0 0 VPWR VPWR k07_n7 sky130_fd_sc_hd__inv_1
Xk07_inv8 k07_n7 0 0 VPWR VPWR k07_n8 sky130_fd_sc_hd__inv_1
Xk07_inv9 k07_n8 0 0 VPWR VPWR k07_n9 sky130_fd_sc_hd__inv_1
Xk07_inv10 k07_n9 0 0 VPWR VPWR k07_n10 sky130_fd_sc_hd__inv_1
Xk07_inv11 k07_n10 0 0 VPWR VPWR k07_n11 sky130_fd_sc_hd__inv_1
Xk07_inv12 k07_n11 0 0 VPWR VPWR k07_n12 sky130_fd_sc_hd__inv_1
Xk07_inv13 k07_n12 0 0 VPWR VPWR k07_n13 sky130_fd_sc_hd__inv_1
Xk07_inv14 k07_n13 0 0 VPWR VPWR k07_n14 sky130_fd_sc_hd__inv_1
Xk07_inv15 k07_n14 0 0 VPWR VPWR k07_n15 sky130_fd_sc_hd__inv_1
Xk07_inv16 k07_n15 0 0 VPWR VPWR k07_n16 sky130_fd_sc_hd__inv_1
Xk07_inv17 k07_n16 0 0 VPWR VPWR k07_n17 sky130_fd_sc_hd__inv_1
Xk07_inv18 k07_n17 0 0 VPWR VPWR k07_n18 sky130_fd_sc_hd__inv_1
Xk07_inv19 k07_n18 0 0 VPWR VPWR k07_n19 sky130_fd_sc_hd__inv_1
Xk07_inv20 k07_n19 0 0 VPWR VPWR k07_n20 sky130_fd_sc_hd__inv_1
Xk07_inv21 k07_n20 0 0 VPWR VPWR k07_n21 sky130_fd_sc_hd__inv_1
Xk07_inv22 k07_n21 0 0 VPWR VPWR k07_n22 sky130_fd_sc_hd__inv_1
Xk07_inv23 k07_n22 0 0 VPWR VPWR k07_n23 sky130_fd_sc_hd__inv_1
Xk07_inv24 k07_n23 0 0 VPWR VPWR k07_n24 sky130_fd_sc_hd__inv_1
Xk07_inv25 k07_n24 0 0 VPWR VPWR k07_n25 sky130_fd_sc_hd__inv_1
Xk07_inv26 k07_n25 0 0 VPWR VPWR k07_n26 sky130_fd_sc_hd__inv_1
Xk07_inv27 k07_n26 0 0 VPWR VPWR k07_n27 sky130_fd_sc_hd__inv_1
Xk07_inv28 k07_n27 0 0 VPWR VPWR k07_n28 sky130_fd_sc_hd__inv_1
Xk07_inv29 k07_n28 0 0 VPWR VPWR k07_n29 sky130_fd_sc_hd__inv_1
Xk07_inv30 k07_n29 0 0 VPWR VPWR k07_n30 sky130_fd_sc_hd__inv_1
Xk07_buf k07_n15 0 0 VPWR VPWR k07_net2 sky130_fd_sc_hd__buf_1
Xk07_dlyout k07_net2 0 0 VPWR VPWR k07_omac sky130_fd_sc_hd__clkdlybuf4s25_1
Ck07_n0 k07_n0 0 3.068490e-16
Ck07_n1 k07_n1 0 2.255910e-16
Ck07_n2 k07_n2 0 1.067930e-16
Ck07_n3 k07_n3 0 6.592350e-16
Ck07_n4 k07_n4 0 4.933900e-16
Ck07_n5 k07_n5 0 2.255700e-16
Ck07_n6 k07_n6 0 5.757220e-16
Ck07_n7 k07_n7 0 5.002390e-16
Ck07_n8 k07_n8 0 1.628300e-16
Ck07_n9 k07_n9 0 3.187680e-16
Ck07_n10 k07_n10 0 1.067930e-16
Ck07_n11 k07_n11 0 1.067930e-16
Ck07_n12 k07_n12 0 1.233470e-16
Ck07_n13 k07_n13 0 1.067930e-16
Ck07_n14 k07_n14 0 1.231760e-16
Ck07_n15 k07_n15 0 5.925330e-16
Ck07_n16 k07_n16 0 2.188230e-16
Ck07_n17 k07_n17 0 5.031700e-16
Ck07_n18 k07_n18 0 7.865940e-16
Ck07_n19 k07_n19 0 6.291400e-16
Ck07_n20 k07_n20 0 1.820890e-16
Ck07_n21 k07_n21 0 4.232880e-16
Ck07_n22 k07_n22 0 1.178430e-16
Ck07_n23 k07_n23 0 1.629830e-16
Ck07_n24 k07_n24 0 8.774660e-16
Ck07_n25 k07_n25 0 1.574940e-16
Ck07_n26 k07_n26 0 7.696420e-16
Ck07_n27 k07_n27 0 4.887020e-16
Ck07_n28 k07_n28 0 2.381970e-16
Ck07_n29 k07_n29 0 1.081190e-16
Ck07_n30 k07_n30 0 6.156450e-16
Ck07_net1 k07_net1 0 5.083940e-16
Ck07_net2 k07_net2 0 7.365850e-16
Ck07_en k07_epin 0 1.128140e-15
Ck07_out k07_omac 0 1.942570e-15
Rk07_o0 k07_omac k07_orx 48.5812
Ck07_og0 k07_orx 0 1.247750e-15
Ck07_og1 k07_omac 0 1.247750e-15
Ck07_ox0 k07_orx 0 5.351660e-17
Ck07_ox1 k07_orx 0 3.996140e-18
Ck07_ox2 k07_orx 0 2.671320e-17
Ck07_ox3 k07_orx 0 3.187840e-15
Ck07_ox4 k07_orx 0 1.857790e-16
Xk07_rcv 0 0 ONE k07_orx 0 0 0 VPWR VPWR k07_rxout sky130_fd_sc_hd__a221o_2
Ck07_rxout k07_rxout 0 1.194940e-14

* --- instance 8: u_rob8, enable from _331_.X, output into _461_.A1 ---
Xk08_drv EN ONE ONE 0 0 VPWR VPWR k08_edrv sky130_fd_sc_hd__and3_2
Rk08_e0 k08_edrv k08_e327_8 19.6750
Rk08_e1 k08_e327_8 k08_e327_14 49.7500
Rk08_e2 k08_e327_14 k08_epin 11.2679
Ck08_eg0 k08_epin 0 3.356740e-16
Ck08_eg1 k08_edrv 0 7.908540e-17
Ck08_eg2 k08_e327_14 0 2.516680e-15
Ck08_eg3 k08_e327_8 0 2.260090e-15
Ck08_ex0 k08_e327_8 0 3.638370e-16
Ck08_ex1 k08_e327_8 0 1.436250e-16
Ck08_ex2 k08_e327_8 0 6.267140e-16
Ck08_ex3 k08_e327_14 0 5.371650e-16
Xk08_dlyin k08_epin 0 0 VPWR VPWR k08_net1 sky130_fd_sc_hd__clkdlybuf4s25_1
Xk08_nand k08_net1 k08_n30 0 0 VPWR VPWR k08_n0 sky130_fd_sc_hd__nand2_1
Xk08_inv1 k08_n0 0 0 VPWR VPWR k08_n1 sky130_fd_sc_hd__inv_1
Xk08_inv2 k08_n1 0 0 VPWR VPWR k08_n2 sky130_fd_sc_hd__inv_1
Xk08_inv3 k08_n2 0 0 VPWR VPWR k08_n3 sky130_fd_sc_hd__inv_1
Xk08_inv4 k08_n3 0 0 VPWR VPWR k08_n4 sky130_fd_sc_hd__inv_1
Xk08_inv5 k08_n4 0 0 VPWR VPWR k08_n5 sky130_fd_sc_hd__inv_1
Xk08_inv6 k08_n5 0 0 VPWR VPWR k08_n6 sky130_fd_sc_hd__inv_1
Xk08_inv7 k08_n6 0 0 VPWR VPWR k08_n7 sky130_fd_sc_hd__inv_1
Xk08_inv8 k08_n7 0 0 VPWR VPWR k08_n8 sky130_fd_sc_hd__inv_1
Xk08_inv9 k08_n8 0 0 VPWR VPWR k08_n9 sky130_fd_sc_hd__inv_1
Xk08_inv10 k08_n9 0 0 VPWR VPWR k08_n10 sky130_fd_sc_hd__inv_1
Xk08_inv11 k08_n10 0 0 VPWR VPWR k08_n11 sky130_fd_sc_hd__inv_1
Xk08_inv12 k08_n11 0 0 VPWR VPWR k08_n12 sky130_fd_sc_hd__inv_1
Xk08_inv13 k08_n12 0 0 VPWR VPWR k08_n13 sky130_fd_sc_hd__inv_1
Xk08_inv14 k08_n13 0 0 VPWR VPWR k08_n14 sky130_fd_sc_hd__inv_1
Xk08_inv15 k08_n14 0 0 VPWR VPWR k08_n15 sky130_fd_sc_hd__inv_1
Xk08_inv16 k08_n15 0 0 VPWR VPWR k08_n16 sky130_fd_sc_hd__inv_1
Xk08_inv17 k08_n16 0 0 VPWR VPWR k08_n17 sky130_fd_sc_hd__inv_1
Xk08_inv18 k08_n17 0 0 VPWR VPWR k08_n18 sky130_fd_sc_hd__inv_1
Xk08_inv19 k08_n18 0 0 VPWR VPWR k08_n19 sky130_fd_sc_hd__inv_1
Xk08_inv20 k08_n19 0 0 VPWR VPWR k08_n20 sky130_fd_sc_hd__inv_1
Xk08_inv21 k08_n20 0 0 VPWR VPWR k08_n21 sky130_fd_sc_hd__inv_1
Xk08_inv22 k08_n21 0 0 VPWR VPWR k08_n22 sky130_fd_sc_hd__inv_1
Xk08_inv23 k08_n22 0 0 VPWR VPWR k08_n23 sky130_fd_sc_hd__inv_1
Xk08_inv24 k08_n23 0 0 VPWR VPWR k08_n24 sky130_fd_sc_hd__inv_1
Xk08_inv25 k08_n24 0 0 VPWR VPWR k08_n25 sky130_fd_sc_hd__inv_1
Xk08_inv26 k08_n25 0 0 VPWR VPWR k08_n26 sky130_fd_sc_hd__inv_1
Xk08_inv27 k08_n26 0 0 VPWR VPWR k08_n27 sky130_fd_sc_hd__inv_1
Xk08_inv28 k08_n27 0 0 VPWR VPWR k08_n28 sky130_fd_sc_hd__inv_1
Xk08_inv29 k08_n28 0 0 VPWR VPWR k08_n29 sky130_fd_sc_hd__inv_1
Xk08_inv30 k08_n29 0 0 VPWR VPWR k08_n30 sky130_fd_sc_hd__inv_1
Xk08_buf k08_n15 0 0 VPWR VPWR k08_net2 sky130_fd_sc_hd__buf_1
Xk08_dlyout k08_net2 0 0 VPWR VPWR k08_omac sky130_fd_sc_hd__clkdlybuf4s25_1
Ck08_n0 k08_n0 0 3.068490e-16
Ck08_n1 k08_n1 0 2.255910e-16
Ck08_n2 k08_n2 0 1.067930e-16
Ck08_n3 k08_n3 0 6.592350e-16
Ck08_n4 k08_n4 0 4.933900e-16
Ck08_n5 k08_n5 0 2.255700e-16
Ck08_n6 k08_n6 0 5.757220e-16
Ck08_n7 k08_n7 0 5.002390e-16
Ck08_n8 k08_n8 0 1.628300e-16
Ck08_n9 k08_n9 0 3.187680e-16
Ck08_n10 k08_n10 0 1.067930e-16
Ck08_n11 k08_n11 0 1.067930e-16
Ck08_n12 k08_n12 0 1.233470e-16
Ck08_n13 k08_n13 0 1.067930e-16
Ck08_n14 k08_n14 0 1.231760e-16
Ck08_n15 k08_n15 0 5.925330e-16
Ck08_n16 k08_n16 0 2.188230e-16
Ck08_n17 k08_n17 0 5.031700e-16
Ck08_n18 k08_n18 0 7.865940e-16
Ck08_n19 k08_n19 0 6.291400e-16
Ck08_n20 k08_n20 0 1.820890e-16
Ck08_n21 k08_n21 0 4.232880e-16
Ck08_n22 k08_n22 0 1.178430e-16
Ck08_n23 k08_n23 0 1.629830e-16
Ck08_n24 k08_n24 0 8.774660e-16
Ck08_n25 k08_n25 0 1.574940e-16
Ck08_n26 k08_n26 0 7.696420e-16
Ck08_n27 k08_n27 0 4.887020e-16
Ck08_n28 k08_n28 0 2.381970e-16
Ck08_n29 k08_n29 0 1.081190e-16
Ck08_n30 k08_n30 0 6.156450e-16
Ck08_net1 k08_net1 0 5.083940e-16
Ck08_net2 k08_net2 0 7.365850e-16
Ck08_en k08_epin 0 1.128140e-15
Ck08_out k08_omac 0 1.942570e-15
Rk08_o0 k08_omac k08_o343_11 11.4286
Rk08_o1 k08_o343_11 k08_o343_13 195.6250
Rk08_o2 k08_o343_13 k08_orx 25.4071
Ck08_og0 k08_orx 0 2.231690e-16
Ck08_og1 k08_omac 0 3.388000e-16
Ck08_og2 k08_o343_13 0 4.124650e-15
Ck08_og3 k08_o343_11 0 4.240280e-15
Ck08_ox0 k08_orx 0 5.443090e-16
Ck08_ox1 k08_orx 0 9.195220e-17
Ck08_ox2 k08_orx 0 1.344170e-16
Ck08_ox3 k08_o343_13 0 6.998300e-15
Ck08_ox4 k08_o343_13 0 1.729310e-14
Ck08_ox5 k08_o343_13 0 5.407770e-16
Ck08_ox6 k08_o343_13 0 2.013570e-15
Ck08_ox7 k08_o343_13 0 1.829450e-15
Ck08_ox8 k08_o343_13 0 1.350120e-16
Ck08_ox9 k08_o343_13 0 1.203750e-15
Ck08_ox10 k08_o343_13 0 5.678640e-15
Xk08_rcv k08_orx ONE 0 0 0 0 0 VPWR VPWR k08_rxout sky130_fd_sc_hd__a221o_2
Ck08_rxout k08_rxout 0 4.011830e-15

* --- instance 9: u_rob9, enable from _332_.X, output into _460_.A1 ---
Xk09_drv EN ONE ONE 0 0 VPWR VPWR k09_edrv sky130_fd_sc_hd__and3_2
Rk09_e0 k09_edrv k09_epin 36.9091
Ck09_eg0 k09_epin 0 2.281990e-15
Ck09_eg1 k09_edrv 0 2.281990e-15
Ck09_ex0 k09_epin 0 6.007330e-16
Ck09_ex1 k09_epin 0 2.061120e-17
Ck09_ex2 k09_epin 0 2.219720e-17
Xk09_dlyin k09_epin 0 0 VPWR VPWR k09_net1 sky130_fd_sc_hd__clkdlybuf4s25_1
Xk09_nand k09_net1 k09_n30 0 0 VPWR VPWR k09_n0 sky130_fd_sc_hd__nand2_1
Xk09_inv1 k09_n0 0 0 VPWR VPWR k09_n1 sky130_fd_sc_hd__inv_1
Xk09_inv2 k09_n1 0 0 VPWR VPWR k09_n2 sky130_fd_sc_hd__inv_1
Xk09_inv3 k09_n2 0 0 VPWR VPWR k09_n3 sky130_fd_sc_hd__inv_1
Xk09_inv4 k09_n3 0 0 VPWR VPWR k09_n4 sky130_fd_sc_hd__inv_1
Xk09_inv5 k09_n4 0 0 VPWR VPWR k09_n5 sky130_fd_sc_hd__inv_1
Xk09_inv6 k09_n5 0 0 VPWR VPWR k09_n6 sky130_fd_sc_hd__inv_1
Xk09_inv7 k09_n6 0 0 VPWR VPWR k09_n7 sky130_fd_sc_hd__inv_1
Xk09_inv8 k09_n7 0 0 VPWR VPWR k09_n8 sky130_fd_sc_hd__inv_1
Xk09_inv9 k09_n8 0 0 VPWR VPWR k09_n9 sky130_fd_sc_hd__inv_1
Xk09_inv10 k09_n9 0 0 VPWR VPWR k09_n10 sky130_fd_sc_hd__inv_1
Xk09_inv11 k09_n10 0 0 VPWR VPWR k09_n11 sky130_fd_sc_hd__inv_1
Xk09_inv12 k09_n11 0 0 VPWR VPWR k09_n12 sky130_fd_sc_hd__inv_1
Xk09_inv13 k09_n12 0 0 VPWR VPWR k09_n13 sky130_fd_sc_hd__inv_1
Xk09_inv14 k09_n13 0 0 VPWR VPWR k09_n14 sky130_fd_sc_hd__inv_1
Xk09_inv15 k09_n14 0 0 VPWR VPWR k09_n15 sky130_fd_sc_hd__inv_1
Xk09_inv16 k09_n15 0 0 VPWR VPWR k09_n16 sky130_fd_sc_hd__inv_1
Xk09_inv17 k09_n16 0 0 VPWR VPWR k09_n17 sky130_fd_sc_hd__inv_1
Xk09_inv18 k09_n17 0 0 VPWR VPWR k09_n18 sky130_fd_sc_hd__inv_1
Xk09_inv19 k09_n18 0 0 VPWR VPWR k09_n19 sky130_fd_sc_hd__inv_1
Xk09_inv20 k09_n19 0 0 VPWR VPWR k09_n20 sky130_fd_sc_hd__inv_1
Xk09_inv21 k09_n20 0 0 VPWR VPWR k09_n21 sky130_fd_sc_hd__inv_1
Xk09_inv22 k09_n21 0 0 VPWR VPWR k09_n22 sky130_fd_sc_hd__inv_1
Xk09_inv23 k09_n22 0 0 VPWR VPWR k09_n23 sky130_fd_sc_hd__inv_1
Xk09_inv24 k09_n23 0 0 VPWR VPWR k09_n24 sky130_fd_sc_hd__inv_1
Xk09_inv25 k09_n24 0 0 VPWR VPWR k09_n25 sky130_fd_sc_hd__inv_1
Xk09_inv26 k09_n25 0 0 VPWR VPWR k09_n26 sky130_fd_sc_hd__inv_1
Xk09_inv27 k09_n26 0 0 VPWR VPWR k09_n27 sky130_fd_sc_hd__inv_1
Xk09_inv28 k09_n27 0 0 VPWR VPWR k09_n28 sky130_fd_sc_hd__inv_1
Xk09_inv29 k09_n28 0 0 VPWR VPWR k09_n29 sky130_fd_sc_hd__inv_1
Xk09_inv30 k09_n29 0 0 VPWR VPWR k09_n30 sky130_fd_sc_hd__inv_1
Xk09_buf k09_n15 0 0 VPWR VPWR k09_net2 sky130_fd_sc_hd__buf_1
Xk09_dlyout k09_net2 0 0 VPWR VPWR k09_omac sky130_fd_sc_hd__clkdlybuf4s25_1
Ck09_n0 k09_n0 0 3.068490e-16
Ck09_n1 k09_n1 0 2.255910e-16
Ck09_n2 k09_n2 0 1.067930e-16
Ck09_n3 k09_n3 0 6.592350e-16
Ck09_n4 k09_n4 0 4.933900e-16
Ck09_n5 k09_n5 0 2.255700e-16
Ck09_n6 k09_n6 0 5.757220e-16
Ck09_n7 k09_n7 0 5.002390e-16
Ck09_n8 k09_n8 0 1.628300e-16
Ck09_n9 k09_n9 0 3.187680e-16
Ck09_n10 k09_n10 0 1.067930e-16
Ck09_n11 k09_n11 0 1.067930e-16
Ck09_n12 k09_n12 0 1.233470e-16
Ck09_n13 k09_n13 0 1.067930e-16
Ck09_n14 k09_n14 0 1.231760e-16
Ck09_n15 k09_n15 0 5.925330e-16
Ck09_n16 k09_n16 0 2.188230e-16
Ck09_n17 k09_n17 0 5.031700e-16
Ck09_n18 k09_n18 0 7.865940e-16
Ck09_n19 k09_n19 0 6.291400e-16
Ck09_n20 k09_n20 0 1.820890e-16
Ck09_n21 k09_n21 0 4.232880e-16
Ck09_n22 k09_n22 0 1.178430e-16
Ck09_n23 k09_n23 0 1.629830e-16
Ck09_n24 k09_n24 0 8.774660e-16
Ck09_n25 k09_n25 0 1.574940e-16
Ck09_n26 k09_n26 0 7.696420e-16
Ck09_n27 k09_n27 0 4.887020e-16
Ck09_n28 k09_n28 0 2.381970e-16
Ck09_n29 k09_n29 0 1.081190e-16
Ck09_n30 k09_n30 0 6.156450e-16
Ck09_net1 k09_net1 0 5.083940e-16
Ck09_net2 k09_net2 0 7.365850e-16
Ck09_en k09_epin 0 1.128140e-15
Ck09_out k09_omac 0 1.942570e-15
Rk09_o0 k09_omac k09_o344_11 11.1161
Rk09_o1 k09_o344_11 k09_o344_13 65.8393
Rk09_o2 k09_o344_13 k09_o344_19 49.8036
Rk09_o3 k09_o344_19 k09_orx 9.3000
Ck09_og0 k09_omac 0 3.527700e-16
Ck09_og1 k09_o344_19 0 1.155970e-15
Ck09_og2 k09_o344_13 0 2.275790e-15
Ck09_og3 k09_o344_11 0 1.472580e-15
Ck09_ox0 k09_o344_13 0 1.056880e-15
Ck09_ox1 k09_o344_13 0 2.029590e-15
Ck09_ox2 k09_o344_19 0 7.415130e-16
Ck09_ox3 k09_o344_19 0 2.966990e-16
Ck09_ox4 k09_o344_13 0 3.372660e-16
Ck09_ox5 k09_o344_13 0 1.455860e-16
Ck09_ox6 k09_o344_19 0 6.674230e-16
Ck09_ox7 k09_o344_13 0 6.565340e-16
Ck09_ox8 k09_o344_19 0 1.192480e-15
Ck09_ox9 k09_o344_13 0 6.998300e-15
Xk09_rcv k09_orx ONE 0 0 0 0 VPWR VPWR k09_rxout sky130_fd_sc_hd__a22o_2
Ck09_rxout k09_rxout 0 1.938200e-14

* --- instance 10: u_rob10, enable from _333_.X, output into _460_.B2 ---
Xk10_drv EN ONE ONE 0 0 VPWR VPWR k10_edrv sky130_fd_sc_hd__and3_2
Rk10_e0 k10_edrv k10_epin 41.1747
Ck10_eg0 k10_epin 0 2.637730e-15
Ck10_eg1 k10_edrv 0 2.637730e-15
Ck10_ex0 k10_epin 0 6.354810e-17
Ck10_ex1 k10_epin 0 5.403770e-17
Ck10_ex2 k10_epin 0 4.494200e-16
Ck10_ex3 k10_epin 0 1.573360e-16
Ck10_ex4 k10_epin 0 1.630730e-16
Xk10_dlyin k10_epin 0 0 VPWR VPWR k10_net1 sky130_fd_sc_hd__clkdlybuf4s25_1
Xk10_nand k10_net1 k10_n30 0 0 VPWR VPWR k10_n0 sky130_fd_sc_hd__nand2_1
Xk10_inv1 k10_n0 0 0 VPWR VPWR k10_n1 sky130_fd_sc_hd__inv_1
Xk10_inv2 k10_n1 0 0 VPWR VPWR k10_n2 sky130_fd_sc_hd__inv_1
Xk10_inv3 k10_n2 0 0 VPWR VPWR k10_n3 sky130_fd_sc_hd__inv_1
Xk10_inv4 k10_n3 0 0 VPWR VPWR k10_n4 sky130_fd_sc_hd__inv_1
Xk10_inv5 k10_n4 0 0 VPWR VPWR k10_n5 sky130_fd_sc_hd__inv_1
Xk10_inv6 k10_n5 0 0 VPWR VPWR k10_n6 sky130_fd_sc_hd__inv_1
Xk10_inv7 k10_n6 0 0 VPWR VPWR k10_n7 sky130_fd_sc_hd__inv_1
Xk10_inv8 k10_n7 0 0 VPWR VPWR k10_n8 sky130_fd_sc_hd__inv_1
Xk10_inv9 k10_n8 0 0 VPWR VPWR k10_n9 sky130_fd_sc_hd__inv_1
Xk10_inv10 k10_n9 0 0 VPWR VPWR k10_n10 sky130_fd_sc_hd__inv_1
Xk10_inv11 k10_n10 0 0 VPWR VPWR k10_n11 sky130_fd_sc_hd__inv_1
Xk10_inv12 k10_n11 0 0 VPWR VPWR k10_n12 sky130_fd_sc_hd__inv_1
Xk10_inv13 k10_n12 0 0 VPWR VPWR k10_n13 sky130_fd_sc_hd__inv_1
Xk10_inv14 k10_n13 0 0 VPWR VPWR k10_n14 sky130_fd_sc_hd__inv_1
Xk10_inv15 k10_n14 0 0 VPWR VPWR k10_n15 sky130_fd_sc_hd__inv_1
Xk10_inv16 k10_n15 0 0 VPWR VPWR k10_n16 sky130_fd_sc_hd__inv_1
Xk10_inv17 k10_n16 0 0 VPWR VPWR k10_n17 sky130_fd_sc_hd__inv_1
Xk10_inv18 k10_n17 0 0 VPWR VPWR k10_n18 sky130_fd_sc_hd__inv_1
Xk10_inv19 k10_n18 0 0 VPWR VPWR k10_n19 sky130_fd_sc_hd__inv_1
Xk10_inv20 k10_n19 0 0 VPWR VPWR k10_n20 sky130_fd_sc_hd__inv_1
Xk10_inv21 k10_n20 0 0 VPWR VPWR k10_n21 sky130_fd_sc_hd__inv_1
Xk10_inv22 k10_n21 0 0 VPWR VPWR k10_n22 sky130_fd_sc_hd__inv_1
Xk10_inv23 k10_n22 0 0 VPWR VPWR k10_n23 sky130_fd_sc_hd__inv_1
Xk10_inv24 k10_n23 0 0 VPWR VPWR k10_n24 sky130_fd_sc_hd__inv_1
Xk10_inv25 k10_n24 0 0 VPWR VPWR k10_n25 sky130_fd_sc_hd__inv_1
Xk10_inv26 k10_n25 0 0 VPWR VPWR k10_n26 sky130_fd_sc_hd__inv_1
Xk10_inv27 k10_n26 0 0 VPWR VPWR k10_n27 sky130_fd_sc_hd__inv_1
Xk10_inv28 k10_n27 0 0 VPWR VPWR k10_n28 sky130_fd_sc_hd__inv_1
Xk10_inv29 k10_n28 0 0 VPWR VPWR k10_n29 sky130_fd_sc_hd__inv_1
Xk10_inv30 k10_n29 0 0 VPWR VPWR k10_n30 sky130_fd_sc_hd__inv_1
Xk10_buf k10_n15 0 0 VPWR VPWR k10_net2 sky130_fd_sc_hd__buf_1
Xk10_dlyout k10_net2 0 0 VPWR VPWR k10_omac sky130_fd_sc_hd__clkdlybuf4s25_1
Ck10_n0 k10_n0 0 3.068490e-16
Ck10_n1 k10_n1 0 2.255910e-16
Ck10_n2 k10_n2 0 1.067930e-16
Ck10_n3 k10_n3 0 6.592350e-16
Ck10_n4 k10_n4 0 4.933900e-16
Ck10_n5 k10_n5 0 2.255700e-16
Ck10_n6 k10_n6 0 5.757220e-16
Ck10_n7 k10_n7 0 5.002390e-16
Ck10_n8 k10_n8 0 1.628300e-16
Ck10_n9 k10_n9 0 3.187680e-16
Ck10_n10 k10_n10 0 1.067930e-16
Ck10_n11 k10_n11 0 1.067930e-16
Ck10_n12 k10_n12 0 1.233470e-16
Ck10_n13 k10_n13 0 1.067930e-16
Ck10_n14 k10_n14 0 1.231760e-16
Ck10_n15 k10_n15 0 5.925330e-16
Ck10_n16 k10_n16 0 2.188230e-16
Ck10_n17 k10_n17 0 5.031700e-16
Ck10_n18 k10_n18 0 7.865940e-16
Ck10_n19 k10_n19 0 6.291400e-16
Ck10_n20 k10_n20 0 1.820890e-16
Ck10_n21 k10_n21 0 4.232880e-16
Ck10_n22 k10_n22 0 1.178430e-16
Ck10_n23 k10_n23 0 1.629830e-16
Ck10_n24 k10_n24 0 8.774660e-16
Ck10_n25 k10_n25 0 1.574940e-16
Ck10_n26 k10_n26 0 7.696420e-16
Ck10_n27 k10_n27 0 4.887020e-16
Ck10_n28 k10_n28 0 2.381970e-16
Ck10_n29 k10_n29 0 1.081190e-16
Ck10_n30 k10_n30 0 6.156450e-16
Ck10_net1 k10_net1 0 5.083940e-16
Ck10_net2 k10_net2 0 7.365850e-16
Ck10_en k10_epin 0 1.128140e-15
Ck10_out k10_omac 0 1.942570e-15
Rk10_o0 k10_omac k10_o330_11 26.9821
Rk10_o1 k10_o330_11 k10_o330_15 44.6964
Rk10_o2 k10_o330_15 k10_orx 9.3000
Ck10_og0 k10_omac 0 5.671040e-16
Ck10_og1 k10_o330_15 0 9.101640e-16
Ck10_og2 k10_o330_11 0 1.477270e-15
Ck10_ox0 k10_o330_11 0 6.565340e-16
Ck10_ox1 k10_o330_11 0 1.828990e-16
Ck10_ox2 k10_o330_11 0 1.187810e-15
Ck10_ox3 k10_o330_15 0 1.192480e-15
Ck10_ox4 k10_o330_15 0 3.170090e-15
Ck10_ox5 k10_o330_15 0 2.278080e-16
Xk10_rcv 0 0 ONE k10_orx 0 0 VPWR VPWR k10_rxout sky130_fd_sc_hd__a22o_2
Ck10_rxout k10_rxout 0 1.938200e-14

* --- instance 11: u_rob11, enable from _334_.X, output into _461_.B2 ---
Xk11_drv EN ONE ONE 0 0 VPWR VPWR k11_edrv sky130_fd_sc_hd__and3_2
Rk11_e0 k11_edrv k11_epin 44.8268
Ck11_eg0 k11_epin 0 1.438830e-15
Ck11_eg1 k11_edrv 0 1.438830e-15
Ck11_ex0 k11_epin 0 8.660630e-17
Ck11_ex1 k11_epin 0 1.246520e-15
Xk11_dlyin k11_epin 0 0 VPWR VPWR k11_net1 sky130_fd_sc_hd__clkdlybuf4s25_1
Xk11_nand k11_net1 k11_n30 0 0 VPWR VPWR k11_n0 sky130_fd_sc_hd__nand2_1
Xk11_inv1 k11_n0 0 0 VPWR VPWR k11_n1 sky130_fd_sc_hd__inv_1
Xk11_inv2 k11_n1 0 0 VPWR VPWR k11_n2 sky130_fd_sc_hd__inv_1
Xk11_inv3 k11_n2 0 0 VPWR VPWR k11_n3 sky130_fd_sc_hd__inv_1
Xk11_inv4 k11_n3 0 0 VPWR VPWR k11_n4 sky130_fd_sc_hd__inv_1
Xk11_inv5 k11_n4 0 0 VPWR VPWR k11_n5 sky130_fd_sc_hd__inv_1
Xk11_inv6 k11_n5 0 0 VPWR VPWR k11_n6 sky130_fd_sc_hd__inv_1
Xk11_inv7 k11_n6 0 0 VPWR VPWR k11_n7 sky130_fd_sc_hd__inv_1
Xk11_inv8 k11_n7 0 0 VPWR VPWR k11_n8 sky130_fd_sc_hd__inv_1
Xk11_inv9 k11_n8 0 0 VPWR VPWR k11_n9 sky130_fd_sc_hd__inv_1
Xk11_inv10 k11_n9 0 0 VPWR VPWR k11_n10 sky130_fd_sc_hd__inv_1
Xk11_inv11 k11_n10 0 0 VPWR VPWR k11_n11 sky130_fd_sc_hd__inv_1
Xk11_inv12 k11_n11 0 0 VPWR VPWR k11_n12 sky130_fd_sc_hd__inv_1
Xk11_inv13 k11_n12 0 0 VPWR VPWR k11_n13 sky130_fd_sc_hd__inv_1
Xk11_inv14 k11_n13 0 0 VPWR VPWR k11_n14 sky130_fd_sc_hd__inv_1
Xk11_inv15 k11_n14 0 0 VPWR VPWR k11_n15 sky130_fd_sc_hd__inv_1
Xk11_inv16 k11_n15 0 0 VPWR VPWR k11_n16 sky130_fd_sc_hd__inv_1
Xk11_inv17 k11_n16 0 0 VPWR VPWR k11_n17 sky130_fd_sc_hd__inv_1
Xk11_inv18 k11_n17 0 0 VPWR VPWR k11_n18 sky130_fd_sc_hd__inv_1
Xk11_inv19 k11_n18 0 0 VPWR VPWR k11_n19 sky130_fd_sc_hd__inv_1
Xk11_inv20 k11_n19 0 0 VPWR VPWR k11_n20 sky130_fd_sc_hd__inv_1
Xk11_inv21 k11_n20 0 0 VPWR VPWR k11_n21 sky130_fd_sc_hd__inv_1
Xk11_inv22 k11_n21 0 0 VPWR VPWR k11_n22 sky130_fd_sc_hd__inv_1
Xk11_inv23 k11_n22 0 0 VPWR VPWR k11_n23 sky130_fd_sc_hd__inv_1
Xk11_inv24 k11_n23 0 0 VPWR VPWR k11_n24 sky130_fd_sc_hd__inv_1
Xk11_inv25 k11_n24 0 0 VPWR VPWR k11_n25 sky130_fd_sc_hd__inv_1
Xk11_inv26 k11_n25 0 0 VPWR VPWR k11_n26 sky130_fd_sc_hd__inv_1
Xk11_inv27 k11_n26 0 0 VPWR VPWR k11_n27 sky130_fd_sc_hd__inv_1
Xk11_inv28 k11_n27 0 0 VPWR VPWR k11_n28 sky130_fd_sc_hd__inv_1
Xk11_inv29 k11_n28 0 0 VPWR VPWR k11_n29 sky130_fd_sc_hd__inv_1
Xk11_inv30 k11_n29 0 0 VPWR VPWR k11_n30 sky130_fd_sc_hd__inv_1
Xk11_buf k11_n15 0 0 VPWR VPWR k11_net2 sky130_fd_sc_hd__buf_1
Xk11_dlyout k11_net2 0 0 VPWR VPWR k11_omac sky130_fd_sc_hd__clkdlybuf4s25_1
Ck11_n0 k11_n0 0 3.068490e-16
Ck11_n1 k11_n1 0 2.255910e-16
Ck11_n2 k11_n2 0 1.067930e-16
Ck11_n3 k11_n3 0 6.592350e-16
Ck11_n4 k11_n4 0 4.933900e-16
Ck11_n5 k11_n5 0 2.255700e-16
Ck11_n6 k11_n6 0 5.757220e-16
Ck11_n7 k11_n7 0 5.002390e-16
Ck11_n8 k11_n8 0 1.628300e-16
Ck11_n9 k11_n9 0 3.187680e-16
Ck11_n10 k11_n10 0 1.067930e-16
Ck11_n11 k11_n11 0 1.067930e-16
Ck11_n12 k11_n12 0 1.233470e-16
Ck11_n13 k11_n13 0 1.067930e-16
Ck11_n14 k11_n14 0 1.231760e-16
Ck11_n15 k11_n15 0 5.925330e-16
Ck11_n16 k11_n16 0 2.188230e-16
Ck11_n17 k11_n17 0 5.031700e-16
Ck11_n18 k11_n18 0 7.865940e-16
Ck11_n19 k11_n19 0 6.291400e-16
Ck11_n20 k11_n20 0 1.820890e-16
Ck11_n21 k11_n21 0 4.232880e-16
Ck11_n22 k11_n22 0 1.178430e-16
Ck11_n23 k11_n23 0 1.629830e-16
Ck11_n24 k11_n24 0 8.774660e-16
Ck11_n25 k11_n25 0 1.574940e-16
Ck11_n26 k11_n26 0 7.696420e-16
Ck11_n27 k11_n27 0 4.887020e-16
Ck11_n28 k11_n28 0 2.381970e-16
Ck11_n29 k11_n29 0 1.081190e-16
Ck11_n30 k11_n30 0 6.156450e-16
Ck11_net1 k11_net1 0 5.083940e-16
Ck11_net2 k11_net2 0 7.365850e-16
Ck11_en k11_epin 0 1.128140e-15
Ck11_out k11_omac 0 1.942570e-15
Rk11_o0 k11_omac k11_o331_11 44.4196
Rk11_o1 k11_o331_11 k11_orx 25.8937
Ck11_og0 k11_orx 0 4.101930e-16
Ck11_og1 k11_omac 0 1.439630e-15
Ck11_og2 k11_o331_11 0 1.849820e-15
Ck11_ox0 k11_orx 0 4.652570e-16
Ck11_ox1 k11_orx 0 2.281250e-16
Ck11_ox2 k11_orx 0 3.566490e-16
Ck11_ox3 k11_o331_11 0 1.433850e-15
Ck11_ox4 k11_orx 0 9.547980e-18
Xk11_rcv 0 0 ONE k11_orx 0 0 0 VPWR VPWR k11_rxout sky130_fd_sc_hd__a221o_2
Ck11_rxout k11_rxout 0 4.011830e-15

* --- instance 12: u_rob12, enable from _335_.X, output into _466_.A1 ---
Xk12_drv EN ONE ONE 0 0 VPWR VPWR k12_edrv sky130_fd_sc_hd__and3_2
Rk12_e0 k12_edrv k12_epin 35.9227
Ck12_eg0 k12_epin 0 2.364780e-15
Ck12_eg1 k12_edrv 0 2.364780e-15
Ck12_ex0 k12_epin 0 9.323610e-17
Xk12_dlyin k12_epin 0 0 VPWR VPWR k12_net1 sky130_fd_sc_hd__clkdlybuf4s25_1
Xk12_nand k12_net1 k12_n30 0 0 VPWR VPWR k12_n0 sky130_fd_sc_hd__nand2_1
Xk12_inv1 k12_n0 0 0 VPWR VPWR k12_n1 sky130_fd_sc_hd__inv_1
Xk12_inv2 k12_n1 0 0 VPWR VPWR k12_n2 sky130_fd_sc_hd__inv_1
Xk12_inv3 k12_n2 0 0 VPWR VPWR k12_n3 sky130_fd_sc_hd__inv_1
Xk12_inv4 k12_n3 0 0 VPWR VPWR k12_n4 sky130_fd_sc_hd__inv_1
Xk12_inv5 k12_n4 0 0 VPWR VPWR k12_n5 sky130_fd_sc_hd__inv_1
Xk12_inv6 k12_n5 0 0 VPWR VPWR k12_n6 sky130_fd_sc_hd__inv_1
Xk12_inv7 k12_n6 0 0 VPWR VPWR k12_n7 sky130_fd_sc_hd__inv_1
Xk12_inv8 k12_n7 0 0 VPWR VPWR k12_n8 sky130_fd_sc_hd__inv_1
Xk12_inv9 k12_n8 0 0 VPWR VPWR k12_n9 sky130_fd_sc_hd__inv_1
Xk12_inv10 k12_n9 0 0 VPWR VPWR k12_n10 sky130_fd_sc_hd__inv_1
Xk12_inv11 k12_n10 0 0 VPWR VPWR k12_n11 sky130_fd_sc_hd__inv_1
Xk12_inv12 k12_n11 0 0 VPWR VPWR k12_n12 sky130_fd_sc_hd__inv_1
Xk12_inv13 k12_n12 0 0 VPWR VPWR k12_n13 sky130_fd_sc_hd__inv_1
Xk12_inv14 k12_n13 0 0 VPWR VPWR k12_n14 sky130_fd_sc_hd__inv_1
Xk12_inv15 k12_n14 0 0 VPWR VPWR k12_n15 sky130_fd_sc_hd__inv_1
Xk12_inv16 k12_n15 0 0 VPWR VPWR k12_n16 sky130_fd_sc_hd__inv_1
Xk12_inv17 k12_n16 0 0 VPWR VPWR k12_n17 sky130_fd_sc_hd__inv_1
Xk12_inv18 k12_n17 0 0 VPWR VPWR k12_n18 sky130_fd_sc_hd__inv_1
Xk12_inv19 k12_n18 0 0 VPWR VPWR k12_n19 sky130_fd_sc_hd__inv_1
Xk12_inv20 k12_n19 0 0 VPWR VPWR k12_n20 sky130_fd_sc_hd__inv_1
Xk12_inv21 k12_n20 0 0 VPWR VPWR k12_n21 sky130_fd_sc_hd__inv_1
Xk12_inv22 k12_n21 0 0 VPWR VPWR k12_n22 sky130_fd_sc_hd__inv_1
Xk12_inv23 k12_n22 0 0 VPWR VPWR k12_n23 sky130_fd_sc_hd__inv_1
Xk12_inv24 k12_n23 0 0 VPWR VPWR k12_n24 sky130_fd_sc_hd__inv_1
Xk12_inv25 k12_n24 0 0 VPWR VPWR k12_n25 sky130_fd_sc_hd__inv_1
Xk12_inv26 k12_n25 0 0 VPWR VPWR k12_n26 sky130_fd_sc_hd__inv_1
Xk12_inv27 k12_n26 0 0 VPWR VPWR k12_n27 sky130_fd_sc_hd__inv_1
Xk12_inv28 k12_n27 0 0 VPWR VPWR k12_n28 sky130_fd_sc_hd__inv_1
Xk12_inv29 k12_n28 0 0 VPWR VPWR k12_n29 sky130_fd_sc_hd__inv_1
Xk12_inv30 k12_n29 0 0 VPWR VPWR k12_n30 sky130_fd_sc_hd__inv_1
Xk12_buf k12_n15 0 0 VPWR VPWR k12_net2 sky130_fd_sc_hd__buf_1
Xk12_dlyout k12_net2 0 0 VPWR VPWR k12_omac sky130_fd_sc_hd__clkdlybuf4s25_1
Ck12_n0 k12_n0 0 3.068490e-16
Ck12_n1 k12_n1 0 2.255910e-16
Ck12_n2 k12_n2 0 1.067930e-16
Ck12_n3 k12_n3 0 6.592350e-16
Ck12_n4 k12_n4 0 4.933900e-16
Ck12_n5 k12_n5 0 2.255700e-16
Ck12_n6 k12_n6 0 5.757220e-16
Ck12_n7 k12_n7 0 5.002390e-16
Ck12_n8 k12_n8 0 1.628300e-16
Ck12_n9 k12_n9 0 3.187680e-16
Ck12_n10 k12_n10 0 1.067930e-16
Ck12_n11 k12_n11 0 1.067930e-16
Ck12_n12 k12_n12 0 1.233470e-16
Ck12_n13 k12_n13 0 1.067930e-16
Ck12_n14 k12_n14 0 1.231760e-16
Ck12_n15 k12_n15 0 5.925330e-16
Ck12_n16 k12_n16 0 2.188230e-16
Ck12_n17 k12_n17 0 5.031700e-16
Ck12_n18 k12_n18 0 7.865940e-16
Ck12_n19 k12_n19 0 6.291400e-16
Ck12_n20 k12_n20 0 1.820890e-16
Ck12_n21 k12_n21 0 4.232880e-16
Ck12_n22 k12_n22 0 1.178430e-16
Ck12_n23 k12_n23 0 1.629830e-16
Ck12_n24 k12_n24 0 8.774660e-16
Ck12_n25 k12_n25 0 1.574940e-16
Ck12_n26 k12_n26 0 7.696420e-16
Ck12_n27 k12_n27 0 4.887020e-16
Ck12_n28 k12_n28 0 2.381970e-16
Ck12_n29 k12_n29 0 1.081190e-16
Ck12_n30 k12_n30 0 6.156450e-16
Ck12_net1 k12_net1 0 5.083940e-16
Ck12_net2 k12_net2 0 7.365850e-16
Ck12_en k12_epin 0 1.128140e-15
Ck12_out k12_omac 0 1.942570e-15
Rk12_o0 k12_omac k12_o332_15 30.4368
Rk12_o1 k12_o332_15 k12_o332_31 41.5928
Rk12_o2 k12_o332_31 k12_orx 9.3000
Ck12_og0 k12_omac 0 9.136940e-16
Ck12_og1 k12_o332_31 0 5.524080e-15
Ck12_og2 k12_o332_15 0 6.437780e-15
Ck12_ox0 k12_o332_15 0 1.411310e-16
Ck12_ox1 k12_o332_31 0 9.547980e-18
Ck12_ox2 k12_o332_31 0 1.250580e-15
Ck12_ox3 k12_o332_31 0 6.647350e-16
Ck12_ox4 k12_o332_31 0 9.837210e-18
Ck12_ox5 k12_o332_31 0 1.503500e-15
Ck12_ox6 k12_o332_31 0 4.555630e-17
Ck12_ox7 k12_o332_31 0 1.597100e-16
Ck12_ox8 k12_o332_31 0 8.432490e-15
Ck12_ox9 k12_o332_31 0 1.581680e-15
Xk12_rcv k12_orx ONE 0 0 0 0 0 VPWR VPWR k12_rxout sky130_fd_sc_hd__a221o_2
Ck12_rxout k12_rxout 0 1.797670e-14

* --- instance 13: u_rob13, enable from _336_.X, output into _465_.A1 ---
Xk13_drv EN ONE ONE 0 0 VPWR VPWR k13_edrv sky130_fd_sc_hd__and3_2
Rk13_e0 k13_edrv k13_e317_8 15.9786
Rk13_e1 k13_e317_8 k13_e317_12 48.6429
Rk13_e2 k13_e317_12 k13_epin 10.9196
Ck13_eg0 k13_epin 0 1.425070e-16
Ck13_eg1 k13_edrv 0 1.528480e-16
Ck13_eg2 k13_e317_12 0 2.383400e-15
Ck13_eg3 k13_e317_8 0 2.393740e-15
Ck13_ex0 k13_epin 0 3.372660e-16
Ck13_ex1 k13_epin 0 1.219260e-16
Ck13_ex2 k13_epin 0 5.994930e-16
Ck13_ex3 k13_e317_8 0 4.188950e-17
Ck13_ex4 k13_e317_8 0 1.856430e-16
Ck13_ex5 k13_e317_12 0 1.364910e-16
Ck13_ex6 k13_e317_12 0 8.027560e-17
Ck13_ex7 k13_e317_12 0 1.079100e-16
Ck13_ex8 k13_e317_12 0 5.745620e-17
Ck13_ex9 k13_e317_12 0 1.949450e-17
Xk13_dlyin k13_epin 0 0 VPWR VPWR k13_net1 sky130_fd_sc_hd__clkdlybuf4s25_1
Xk13_nand k13_net1 k13_n30 0 0 VPWR VPWR k13_n0 sky130_fd_sc_hd__nand2_1
Xk13_inv1 k13_n0 0 0 VPWR VPWR k13_n1 sky130_fd_sc_hd__inv_1
Xk13_inv2 k13_n1 0 0 VPWR VPWR k13_n2 sky130_fd_sc_hd__inv_1
Xk13_inv3 k13_n2 0 0 VPWR VPWR k13_n3 sky130_fd_sc_hd__inv_1
Xk13_inv4 k13_n3 0 0 VPWR VPWR k13_n4 sky130_fd_sc_hd__inv_1
Xk13_inv5 k13_n4 0 0 VPWR VPWR k13_n5 sky130_fd_sc_hd__inv_1
Xk13_inv6 k13_n5 0 0 VPWR VPWR k13_n6 sky130_fd_sc_hd__inv_1
Xk13_inv7 k13_n6 0 0 VPWR VPWR k13_n7 sky130_fd_sc_hd__inv_1
Xk13_inv8 k13_n7 0 0 VPWR VPWR k13_n8 sky130_fd_sc_hd__inv_1
Xk13_inv9 k13_n8 0 0 VPWR VPWR k13_n9 sky130_fd_sc_hd__inv_1
Xk13_inv10 k13_n9 0 0 VPWR VPWR k13_n10 sky130_fd_sc_hd__inv_1
Xk13_inv11 k13_n10 0 0 VPWR VPWR k13_n11 sky130_fd_sc_hd__inv_1
Xk13_inv12 k13_n11 0 0 VPWR VPWR k13_n12 sky130_fd_sc_hd__inv_1
Xk13_inv13 k13_n12 0 0 VPWR VPWR k13_n13 sky130_fd_sc_hd__inv_1
Xk13_inv14 k13_n13 0 0 VPWR VPWR k13_n14 sky130_fd_sc_hd__inv_1
Xk13_inv15 k13_n14 0 0 VPWR VPWR k13_n15 sky130_fd_sc_hd__inv_1
Xk13_inv16 k13_n15 0 0 VPWR VPWR k13_n16 sky130_fd_sc_hd__inv_1
Xk13_inv17 k13_n16 0 0 VPWR VPWR k13_n17 sky130_fd_sc_hd__inv_1
Xk13_inv18 k13_n17 0 0 VPWR VPWR k13_n18 sky130_fd_sc_hd__inv_1
Xk13_inv19 k13_n18 0 0 VPWR VPWR k13_n19 sky130_fd_sc_hd__inv_1
Xk13_inv20 k13_n19 0 0 VPWR VPWR k13_n20 sky130_fd_sc_hd__inv_1
Xk13_inv21 k13_n20 0 0 VPWR VPWR k13_n21 sky130_fd_sc_hd__inv_1
Xk13_inv22 k13_n21 0 0 VPWR VPWR k13_n22 sky130_fd_sc_hd__inv_1
Xk13_inv23 k13_n22 0 0 VPWR VPWR k13_n23 sky130_fd_sc_hd__inv_1
Xk13_inv24 k13_n23 0 0 VPWR VPWR k13_n24 sky130_fd_sc_hd__inv_1
Xk13_inv25 k13_n24 0 0 VPWR VPWR k13_n25 sky130_fd_sc_hd__inv_1
Xk13_inv26 k13_n25 0 0 VPWR VPWR k13_n26 sky130_fd_sc_hd__inv_1
Xk13_inv27 k13_n26 0 0 VPWR VPWR k13_n27 sky130_fd_sc_hd__inv_1
Xk13_inv28 k13_n27 0 0 VPWR VPWR k13_n28 sky130_fd_sc_hd__inv_1
Xk13_inv29 k13_n28 0 0 VPWR VPWR k13_n29 sky130_fd_sc_hd__inv_1
Xk13_inv30 k13_n29 0 0 VPWR VPWR k13_n30 sky130_fd_sc_hd__inv_1
Xk13_buf k13_n15 0 0 VPWR VPWR k13_net2 sky130_fd_sc_hd__buf_1
Xk13_dlyout k13_net2 0 0 VPWR VPWR k13_omac sky130_fd_sc_hd__clkdlybuf4s25_1
Ck13_n0 k13_n0 0 3.068490e-16
Ck13_n1 k13_n1 0 2.255910e-16
Ck13_n2 k13_n2 0 1.067930e-16
Ck13_n3 k13_n3 0 6.592350e-16
Ck13_n4 k13_n4 0 4.933900e-16
Ck13_n5 k13_n5 0 2.255700e-16
Ck13_n6 k13_n6 0 5.757220e-16
Ck13_n7 k13_n7 0 5.002390e-16
Ck13_n8 k13_n8 0 1.628300e-16
Ck13_n9 k13_n9 0 3.187680e-16
Ck13_n10 k13_n10 0 1.067930e-16
Ck13_n11 k13_n11 0 1.067930e-16
Ck13_n12 k13_n12 0 1.233470e-16
Ck13_n13 k13_n13 0 1.067930e-16
Ck13_n14 k13_n14 0 1.231760e-16
Ck13_n15 k13_n15 0 5.925330e-16
Ck13_n16 k13_n16 0 2.188230e-16
Ck13_n17 k13_n17 0 5.031700e-16
Ck13_n18 k13_n18 0 7.865940e-16
Ck13_n19 k13_n19 0 6.291400e-16
Ck13_n20 k13_n20 0 1.820890e-16
Ck13_n21 k13_n21 0 4.232880e-16
Ck13_n22 k13_n22 0 1.178430e-16
Ck13_n23 k13_n23 0 1.629830e-16
Ck13_n24 k13_n24 0 8.774660e-16
Ck13_n25 k13_n25 0 1.574940e-16
Ck13_n26 k13_n26 0 7.696420e-16
Ck13_n27 k13_n27 0 4.887020e-16
Ck13_n28 k13_n28 0 2.381970e-16
Ck13_n29 k13_n29 0 1.081190e-16
Ck13_n30 k13_n30 0 6.156450e-16
Ck13_net1 k13_net1 0 5.083940e-16
Ck13_net2 k13_net2 0 7.365850e-16
Ck13_en k13_epin 0 1.128140e-15
Ck13_out k13_omac 0 1.942570e-15
Rk13_o0 k13_omac k13_orx 41.6128
Ck13_og0 k13_orx 0 2.145910e-15
Ck13_og1 k13_omac 0 2.145910e-15
Ck13_ox0 k13_orx 0 5.523020e-17
Ck13_ox1 k13_orx 0 1.702430e-16
Ck13_ox2 k13_orx 0 1.988390e-17
Ck13_ox3 k13_orx 0 2.452340e-15
Ck13_ox4 k13_orx 0 2.467920e-15
Ck13_ox5 k13_orx 0 1.257650e-15
Ck13_ox6 k13_orx 0 5.150330e-16
Ck13_ox7 k13_orx 0 1.820110e-17
Ck13_ox8 k13_orx 0 5.676240e-17
Ck13_ox9 k13_orx 0 5.129130e-17
Ck13_ox10 k13_orx 0 9.810720e-16
Ck13_ox11 k13_orx 0 2.133640e-16
Ck13_ox12 k13_orx 0 6.135500e-17
Ck13_ox13 k13_orx 0 4.003490e-17
Xk13_rcv k13_orx ONE 0 0 0 0 VPWR VPWR k13_rxout sky130_fd_sc_hd__a22o_2
Ck13_rxout k13_rxout 0 1.104710e-14

* --- instance 14: u_rob14, enable from _337_.X, output into _465_.B2 ---
Xk14_drv EN ONE ONE 0 0 VPWR VPWR k14_edrv sky130_fd_sc_hd__and3_2
Rk14_e0 k14_edrv k14_epin 38.6932
Ck14_eg0 k14_epin 0 2.535130e-15
Ck14_eg1 k14_edrv 0 2.535130e-15
Ck14_ex0 k14_epin 0 2.231120e-17
Ck14_ex1 k14_epin 0 2.278080e-16
Ck14_ex2 k14_epin 0 1.350120e-16
Ck14_ex3 k14_epin 0 1.455860e-16
Ck14_ex4 k14_epin 0 3.782700e-17
Ck14_ex5 k14_epin 0 4.984220e-17
Ck14_ex6 k14_epin 0 6.336240e-16
Ck14_ex7 k14_epin 0 8.124620e-16
Ck14_ex8 k14_epin 0 2.982970e-16
Ck14_ex9 k14_epin 0 6.956700e-16
Ck14_ex10 k14_epin 0 7.033720e-16
Ck14_ex11 k14_epin 0 6.258900e-18
Xk14_dlyin k14_epin 0 0 VPWR VPWR k14_net1 sky130_fd_sc_hd__clkdlybuf4s25_1
Xk14_nand k14_net1 k14_n30 0 0 VPWR VPWR k14_n0 sky130_fd_sc_hd__nand2_1
Xk14_inv1 k14_n0 0 0 VPWR VPWR k14_n1 sky130_fd_sc_hd__inv_1
Xk14_inv2 k14_n1 0 0 VPWR VPWR k14_n2 sky130_fd_sc_hd__inv_1
Xk14_inv3 k14_n2 0 0 VPWR VPWR k14_n3 sky130_fd_sc_hd__inv_1
Xk14_inv4 k14_n3 0 0 VPWR VPWR k14_n4 sky130_fd_sc_hd__inv_1
Xk14_inv5 k14_n4 0 0 VPWR VPWR k14_n5 sky130_fd_sc_hd__inv_1
Xk14_inv6 k14_n5 0 0 VPWR VPWR k14_n6 sky130_fd_sc_hd__inv_1
Xk14_inv7 k14_n6 0 0 VPWR VPWR k14_n7 sky130_fd_sc_hd__inv_1
Xk14_inv8 k14_n7 0 0 VPWR VPWR k14_n8 sky130_fd_sc_hd__inv_1
Xk14_inv9 k14_n8 0 0 VPWR VPWR k14_n9 sky130_fd_sc_hd__inv_1
Xk14_inv10 k14_n9 0 0 VPWR VPWR k14_n10 sky130_fd_sc_hd__inv_1
Xk14_inv11 k14_n10 0 0 VPWR VPWR k14_n11 sky130_fd_sc_hd__inv_1
Xk14_inv12 k14_n11 0 0 VPWR VPWR k14_n12 sky130_fd_sc_hd__inv_1
Xk14_inv13 k14_n12 0 0 VPWR VPWR k14_n13 sky130_fd_sc_hd__inv_1
Xk14_inv14 k14_n13 0 0 VPWR VPWR k14_n14 sky130_fd_sc_hd__inv_1
Xk14_inv15 k14_n14 0 0 VPWR VPWR k14_n15 sky130_fd_sc_hd__inv_1
Xk14_inv16 k14_n15 0 0 VPWR VPWR k14_n16 sky130_fd_sc_hd__inv_1
Xk14_inv17 k14_n16 0 0 VPWR VPWR k14_n17 sky130_fd_sc_hd__inv_1
Xk14_inv18 k14_n17 0 0 VPWR VPWR k14_n18 sky130_fd_sc_hd__inv_1
Xk14_inv19 k14_n18 0 0 VPWR VPWR k14_n19 sky130_fd_sc_hd__inv_1
Xk14_inv20 k14_n19 0 0 VPWR VPWR k14_n20 sky130_fd_sc_hd__inv_1
Xk14_inv21 k14_n20 0 0 VPWR VPWR k14_n21 sky130_fd_sc_hd__inv_1
Xk14_inv22 k14_n21 0 0 VPWR VPWR k14_n22 sky130_fd_sc_hd__inv_1
Xk14_inv23 k14_n22 0 0 VPWR VPWR k14_n23 sky130_fd_sc_hd__inv_1
Xk14_inv24 k14_n23 0 0 VPWR VPWR k14_n24 sky130_fd_sc_hd__inv_1
Xk14_inv25 k14_n24 0 0 VPWR VPWR k14_n25 sky130_fd_sc_hd__inv_1
Xk14_inv26 k14_n25 0 0 VPWR VPWR k14_n26 sky130_fd_sc_hd__inv_1
Xk14_inv27 k14_n26 0 0 VPWR VPWR k14_n27 sky130_fd_sc_hd__inv_1
Xk14_inv28 k14_n27 0 0 VPWR VPWR k14_n28 sky130_fd_sc_hd__inv_1
Xk14_inv29 k14_n28 0 0 VPWR VPWR k14_n29 sky130_fd_sc_hd__inv_1
Xk14_inv30 k14_n29 0 0 VPWR VPWR k14_n30 sky130_fd_sc_hd__inv_1
Xk14_buf k14_n15 0 0 VPWR VPWR k14_net2 sky130_fd_sc_hd__buf_1
Xk14_dlyout k14_net2 0 0 VPWR VPWR k14_omac sky130_fd_sc_hd__clkdlybuf4s25_1
Ck14_n0 k14_n0 0 3.068490e-16
Ck14_n1 k14_n1 0 2.255910e-16
Ck14_n2 k14_n2 0 1.067930e-16
Ck14_n3 k14_n3 0 6.592350e-16
Ck14_n4 k14_n4 0 4.933900e-16
Ck14_n5 k14_n5 0 2.255700e-16
Ck14_n6 k14_n6 0 5.757220e-16
Ck14_n7 k14_n7 0 5.002390e-16
Ck14_n8 k14_n8 0 1.628300e-16
Ck14_n9 k14_n9 0 3.187680e-16
Ck14_n10 k14_n10 0 1.067930e-16
Ck14_n11 k14_n11 0 1.067930e-16
Ck14_n12 k14_n12 0 1.233470e-16
Ck14_n13 k14_n13 0 1.067930e-16
Ck14_n14 k14_n14 0 1.231760e-16
Ck14_n15 k14_n15 0 5.925330e-16
Ck14_n16 k14_n16 0 2.188230e-16
Ck14_n17 k14_n17 0 5.031700e-16
Ck14_n18 k14_n18 0 7.865940e-16
Ck14_n19 k14_n19 0 6.291400e-16
Ck14_n20 k14_n20 0 1.820890e-16
Ck14_n21 k14_n21 0 4.232880e-16
Ck14_n22 k14_n22 0 1.178430e-16
Ck14_n23 k14_n23 0 1.629830e-16
Ck14_n24 k14_n24 0 8.774660e-16
Ck14_n25 k14_n25 0 1.574940e-16
Ck14_n26 k14_n26 0 7.696420e-16
Ck14_n27 k14_n27 0 4.887020e-16
Ck14_n28 k14_n28 0 2.381970e-16
Ck14_n29 k14_n29 0 1.081190e-16
Ck14_n30 k14_n30 0 6.156450e-16
Ck14_net1 k14_net1 0 5.083940e-16
Ck14_net2 k14_net2 0 7.365850e-16
Ck14_en k14_epin 0 1.128140e-15
Ck14_out k14_omac 0 1.942570e-15
Rk14_o0 k14_omac k14_orx 28.0471
Ck14_og0 k14_orx 0 5.546800e-16
Ck14_og1 k14_omac 0 5.546800e-16
Ck14_ox0 k14_orx 0 9.862100e-17
Ck14_ox1 k14_orx 0 1.202650e-16
Ck14_ox2 k14_orx 0 4.839710e-16
Ck14_ox3 k14_orx 0 3.108850e-17
Ck14_ox4 k14_orx 0 5.257740e-17
Ck14_ox5 k14_orx 0 1.702430e-16
Ck14_ox6 k14_orx 0 1.881750e-17
Ck14_ox7 k14_orx 0 3.476410e-18
Xk14_rcv 0 0 ONE k14_orx 0 0 VPWR VPWR k14_rxout sky130_fd_sc_hd__a22o_2
Ck14_rxout k14_rxout 0 1.104710e-14

* --- instance 15: u_rob15, enable from _338_.X, output into _466_.B2 ---
Xk15_drv EN ONE ONE 0 0 VPWR VPWR k15_edrv sky130_fd_sc_hd__and3_2
Rk15_e0 k15_edrv k15_e319_12 31.9786
Rk15_e1 k15_e319_12 k15_epin 33.5268
Ck15_eg0 k15_epin 0 7.599390e-16
Ck15_eg1 k15_edrv 0 6.685160e-16
Ck15_eg2 k15_e319_12 0 1.428450e-15
Ck15_ex0 k15_epin 0 1.062950e-15
Ck15_ex1 k15_epin 0 1.046040e-15
Ck15_ex2 k15_e319_12 0 6.444000e-17
Ck15_ex3 k15_e319_12 0 1.000730e-17
Ck15_ex4 k15_e319_12 0 6.668250e-16
Ck15_ex5 k15_e319_12 0 9.795020e-17
Ck15_ex6 k15_epin 0 4.078320e-16
Ck15_ex7 k15_epin 0 1.057910e-15
Xk15_dlyin k15_epin 0 0 VPWR VPWR k15_net1 sky130_fd_sc_hd__clkdlybuf4s25_1
Xk15_nand k15_net1 k15_n30 0 0 VPWR VPWR k15_n0 sky130_fd_sc_hd__nand2_1
Xk15_inv1 k15_n0 0 0 VPWR VPWR k15_n1 sky130_fd_sc_hd__inv_1
Xk15_inv2 k15_n1 0 0 VPWR VPWR k15_n2 sky130_fd_sc_hd__inv_1
Xk15_inv3 k15_n2 0 0 VPWR VPWR k15_n3 sky130_fd_sc_hd__inv_1
Xk15_inv4 k15_n3 0 0 VPWR VPWR k15_n4 sky130_fd_sc_hd__inv_1
Xk15_inv5 k15_n4 0 0 VPWR VPWR k15_n5 sky130_fd_sc_hd__inv_1
Xk15_inv6 k15_n5 0 0 VPWR VPWR k15_n6 sky130_fd_sc_hd__inv_1
Xk15_inv7 k15_n6 0 0 VPWR VPWR k15_n7 sky130_fd_sc_hd__inv_1
Xk15_inv8 k15_n7 0 0 VPWR VPWR k15_n8 sky130_fd_sc_hd__inv_1
Xk15_inv9 k15_n8 0 0 VPWR VPWR k15_n9 sky130_fd_sc_hd__inv_1
Xk15_inv10 k15_n9 0 0 VPWR VPWR k15_n10 sky130_fd_sc_hd__inv_1
Xk15_inv11 k15_n10 0 0 VPWR VPWR k15_n11 sky130_fd_sc_hd__inv_1
Xk15_inv12 k15_n11 0 0 VPWR VPWR k15_n12 sky130_fd_sc_hd__inv_1
Xk15_inv13 k15_n12 0 0 VPWR VPWR k15_n13 sky130_fd_sc_hd__inv_1
Xk15_inv14 k15_n13 0 0 VPWR VPWR k15_n14 sky130_fd_sc_hd__inv_1
Xk15_inv15 k15_n14 0 0 VPWR VPWR k15_n15 sky130_fd_sc_hd__inv_1
Xk15_inv16 k15_n15 0 0 VPWR VPWR k15_n16 sky130_fd_sc_hd__inv_1
Xk15_inv17 k15_n16 0 0 VPWR VPWR k15_n17 sky130_fd_sc_hd__inv_1
Xk15_inv18 k15_n17 0 0 VPWR VPWR k15_n18 sky130_fd_sc_hd__inv_1
Xk15_inv19 k15_n18 0 0 VPWR VPWR k15_n19 sky130_fd_sc_hd__inv_1
Xk15_inv20 k15_n19 0 0 VPWR VPWR k15_n20 sky130_fd_sc_hd__inv_1
Xk15_inv21 k15_n20 0 0 VPWR VPWR k15_n21 sky130_fd_sc_hd__inv_1
Xk15_inv22 k15_n21 0 0 VPWR VPWR k15_n22 sky130_fd_sc_hd__inv_1
Xk15_inv23 k15_n22 0 0 VPWR VPWR k15_n23 sky130_fd_sc_hd__inv_1
Xk15_inv24 k15_n23 0 0 VPWR VPWR k15_n24 sky130_fd_sc_hd__inv_1
Xk15_inv25 k15_n24 0 0 VPWR VPWR k15_n25 sky130_fd_sc_hd__inv_1
Xk15_inv26 k15_n25 0 0 VPWR VPWR k15_n26 sky130_fd_sc_hd__inv_1
Xk15_inv27 k15_n26 0 0 VPWR VPWR k15_n27 sky130_fd_sc_hd__inv_1
Xk15_inv28 k15_n27 0 0 VPWR VPWR k15_n28 sky130_fd_sc_hd__inv_1
Xk15_inv29 k15_n28 0 0 VPWR VPWR k15_n29 sky130_fd_sc_hd__inv_1
Xk15_inv30 k15_n29 0 0 VPWR VPWR k15_n30 sky130_fd_sc_hd__inv_1
Xk15_buf k15_n15 0 0 VPWR VPWR k15_net2 sky130_fd_sc_hd__buf_1
Xk15_dlyout k15_net2 0 0 VPWR VPWR k15_omac sky130_fd_sc_hd__clkdlybuf4s25_1
Ck15_n0 k15_n0 0 3.068490e-16
Ck15_n1 k15_n1 0 2.255910e-16
Ck15_n2 k15_n2 0 1.067930e-16
Ck15_n3 k15_n3 0 6.592350e-16
Ck15_n4 k15_n4 0 4.933900e-16
Ck15_n5 k15_n5 0 2.255700e-16
Ck15_n6 k15_n6 0 5.757220e-16
Ck15_n7 k15_n7 0 5.002390e-16
Ck15_n8 k15_n8 0 1.628300e-16
Ck15_n9 k15_n9 0 3.187680e-16
Ck15_n10 k15_n10 0 1.067930e-16
Ck15_n11 k15_n11 0 1.067930e-16
Ck15_n12 k15_n12 0 1.233470e-16
Ck15_n13 k15_n13 0 1.067930e-16
Ck15_n14 k15_n14 0 1.231760e-16
Ck15_n15 k15_n15 0 5.925330e-16
Ck15_n16 k15_n16 0 2.188230e-16
Ck15_n17 k15_n17 0 5.031700e-16
Ck15_n18 k15_n18 0 7.865940e-16
Ck15_n19 k15_n19 0 6.291400e-16
Ck15_n20 k15_n20 0 1.820890e-16
Ck15_n21 k15_n21 0 4.232880e-16
Ck15_n22 k15_n22 0 1.178430e-16
Ck15_n23 k15_n23 0 1.629830e-16
Ck15_n24 k15_n24 0 8.774660e-16
Ck15_n25 k15_n25 0 1.574940e-16
Ck15_n26 k15_n26 0 7.696420e-16
Ck15_n27 k15_n27 0 4.887020e-16
Ck15_n28 k15_n28 0 2.381970e-16
Ck15_n29 k15_n29 0 1.081190e-16
Ck15_n30 k15_n30 0 6.156450e-16
Ck15_net1 k15_net1 0 5.083940e-16
Ck15_net2 k15_net2 0 7.365850e-16
Ck15_en k15_epin 0 1.128140e-15
Ck15_out k15_omac 0 1.942570e-15
Rk15_o0 k15_omac k15_orx 26.5321
Ck15_og0 k15_orx 0 6.137040e-16
Ck15_og1 k15_omac 0 6.137040e-16
Ck15_ox0 k15_orx 0 5.130800e-16
Ck15_ox1 k15_orx 0 7.439940e-17
Ck15_ox2 k15_orx 0 6.497400e-18
Ck15_ox3 k15_orx 0 4.479960e-16
Xk15_rcv 0 0 ONE k15_orx 0 0 0 VPWR VPWR k15_rxout sky130_fd_sc_hd__a221o_2
Ck15_rxout k15_rxout 0 1.797670e-14

.save v(c_out) v(r_out) v(k00_omac) v(k00_orx) v(k01_omac) v(k01_orx) v(k02_omac) v(k02_orx) v(k03_omac) v(k03_orx) v(k04_omac) v(k04_orx) v(k05_omac) v(k05_orx) v(k06_omac) v(k06_orx) v(k07_omac) v(k07_orx) v(k08_omac) v(k08_orx) v(k09_omac) v(k09_orx) v(k10_omac) v(k10_orx) v(k11_omac) v(k11_orx) v(k12_omac) v(k12_orx) v(k13_omac) v(k13_orx) v(k14_omac) v(k14_orx) v(k15_omac) v(k15_orx)
.tran 1p 80n
.control
run
meas tran tp_c TRIG v(c_out) VAL=0.975 RISE=5 TARG v(c_out) VAL=0.975 RISE=25
meas tran hi_c TRIG v(c_out) VAL=0.975 RISE=15 TARG v(c_out) VAL=0.975 FALL=15
meas tran tp_r TRIG v(r_out) VAL=0.975 RISE=5 TARG v(r_out) VAL=0.975 RISE=25
meas tran hi_r TRIG v(r_out) VAL=0.975 RISE=15 TARG v(r_out) VAL=0.975 FALL=15
meas tran tp_k00 TRIG v(k00_omac) VAL=0.975 RISE=5 TARG v(k00_omac) VAL=0.975 RISE=25
meas tran tq_k00 TRIG v(k00_orx) VAL=0.975 RISE=5 TARG v(k00_orx) VAL=0.975 RISE=25
meas tran hi_k00 TRIG v(k00_omac) VAL=0.975 RISE=15 TARG v(k00_omac) VAL=0.975 FALL=15
meas tran hx_k00 TRIG v(k00_orx) VAL=0.975 RISE=15 TARG v(k00_orx) VAL=0.975 FALL=15
meas tran dr_k00 TRIG v(k00_omac) VAL=0.975 RISE=15 TARG v(k00_orx) VAL=0.975 RISE=15
meas tran df_k00 TRIG v(k00_omac) VAL=0.975 FALL=15 TARG v(k00_orx) VAL=0.975 FALL=15
meas tran sm_k00 TRIG v(k00_omac) VAL=0.39 RISE=15 TARG v(k00_omac) VAL=1.56 RISE=15
meas tran sr_k00 TRIG v(k00_orx) VAL=0.39 RISE=15 TARG v(k00_orx) VAL=1.56 RISE=15
meas tran tp_k01 TRIG v(k01_omac) VAL=0.975 RISE=5 TARG v(k01_omac) VAL=0.975 RISE=25
meas tran tq_k01 TRIG v(k01_orx) VAL=0.975 RISE=5 TARG v(k01_orx) VAL=0.975 RISE=25
meas tran hi_k01 TRIG v(k01_omac) VAL=0.975 RISE=15 TARG v(k01_omac) VAL=0.975 FALL=15
meas tran hx_k01 TRIG v(k01_orx) VAL=0.975 RISE=15 TARG v(k01_orx) VAL=0.975 FALL=15
meas tran dr_k01 TRIG v(k01_omac) VAL=0.975 RISE=15 TARG v(k01_orx) VAL=0.975 RISE=15
meas tran df_k01 TRIG v(k01_omac) VAL=0.975 FALL=15 TARG v(k01_orx) VAL=0.975 FALL=15
meas tran sm_k01 TRIG v(k01_omac) VAL=0.39 RISE=15 TARG v(k01_omac) VAL=1.56 RISE=15
meas tran sr_k01 TRIG v(k01_orx) VAL=0.39 RISE=15 TARG v(k01_orx) VAL=1.56 RISE=15
meas tran tp_k02 TRIG v(k02_omac) VAL=0.975 RISE=5 TARG v(k02_omac) VAL=0.975 RISE=25
meas tran tq_k02 TRIG v(k02_orx) VAL=0.975 RISE=5 TARG v(k02_orx) VAL=0.975 RISE=25
meas tran hi_k02 TRIG v(k02_omac) VAL=0.975 RISE=15 TARG v(k02_omac) VAL=0.975 FALL=15
meas tran hx_k02 TRIG v(k02_orx) VAL=0.975 RISE=15 TARG v(k02_orx) VAL=0.975 FALL=15
meas tran dr_k02 TRIG v(k02_omac) VAL=0.975 RISE=15 TARG v(k02_orx) VAL=0.975 RISE=15
meas tran df_k02 TRIG v(k02_omac) VAL=0.975 FALL=15 TARG v(k02_orx) VAL=0.975 FALL=15
meas tran sm_k02 TRIG v(k02_omac) VAL=0.39 RISE=15 TARG v(k02_omac) VAL=1.56 RISE=15
meas tran sr_k02 TRIG v(k02_orx) VAL=0.39 RISE=15 TARG v(k02_orx) VAL=1.56 RISE=15
meas tran tp_k03 TRIG v(k03_omac) VAL=0.975 RISE=5 TARG v(k03_omac) VAL=0.975 RISE=25
meas tran tq_k03 TRIG v(k03_orx) VAL=0.975 RISE=5 TARG v(k03_orx) VAL=0.975 RISE=25
meas tran hi_k03 TRIG v(k03_omac) VAL=0.975 RISE=15 TARG v(k03_omac) VAL=0.975 FALL=15
meas tran hx_k03 TRIG v(k03_orx) VAL=0.975 RISE=15 TARG v(k03_orx) VAL=0.975 FALL=15
meas tran dr_k03 TRIG v(k03_omac) VAL=0.975 RISE=15 TARG v(k03_orx) VAL=0.975 RISE=15
meas tran df_k03 TRIG v(k03_omac) VAL=0.975 FALL=15 TARG v(k03_orx) VAL=0.975 FALL=15
meas tran sm_k03 TRIG v(k03_omac) VAL=0.39 RISE=15 TARG v(k03_omac) VAL=1.56 RISE=15
meas tran sr_k03 TRIG v(k03_orx) VAL=0.39 RISE=15 TARG v(k03_orx) VAL=1.56 RISE=15
meas tran tp_k04 TRIG v(k04_omac) VAL=0.975 RISE=5 TARG v(k04_omac) VAL=0.975 RISE=25
meas tran tq_k04 TRIG v(k04_orx) VAL=0.975 RISE=5 TARG v(k04_orx) VAL=0.975 RISE=25
meas tran hi_k04 TRIG v(k04_omac) VAL=0.975 RISE=15 TARG v(k04_omac) VAL=0.975 FALL=15
meas tran hx_k04 TRIG v(k04_orx) VAL=0.975 RISE=15 TARG v(k04_orx) VAL=0.975 FALL=15
meas tran dr_k04 TRIG v(k04_omac) VAL=0.975 RISE=15 TARG v(k04_orx) VAL=0.975 RISE=15
meas tran df_k04 TRIG v(k04_omac) VAL=0.975 FALL=15 TARG v(k04_orx) VAL=0.975 FALL=15
meas tran sm_k04 TRIG v(k04_omac) VAL=0.39 RISE=15 TARG v(k04_omac) VAL=1.56 RISE=15
meas tran sr_k04 TRIG v(k04_orx) VAL=0.39 RISE=15 TARG v(k04_orx) VAL=1.56 RISE=15
meas tran tp_k05 TRIG v(k05_omac) VAL=0.975 RISE=5 TARG v(k05_omac) VAL=0.975 RISE=25
meas tran tq_k05 TRIG v(k05_orx) VAL=0.975 RISE=5 TARG v(k05_orx) VAL=0.975 RISE=25
meas tran hi_k05 TRIG v(k05_omac) VAL=0.975 RISE=15 TARG v(k05_omac) VAL=0.975 FALL=15
meas tran hx_k05 TRIG v(k05_orx) VAL=0.975 RISE=15 TARG v(k05_orx) VAL=0.975 FALL=15
meas tran dr_k05 TRIG v(k05_omac) VAL=0.975 RISE=15 TARG v(k05_orx) VAL=0.975 RISE=15
meas tran df_k05 TRIG v(k05_omac) VAL=0.975 FALL=15 TARG v(k05_orx) VAL=0.975 FALL=15
meas tran sm_k05 TRIG v(k05_omac) VAL=0.39 RISE=15 TARG v(k05_omac) VAL=1.56 RISE=15
meas tran sr_k05 TRIG v(k05_orx) VAL=0.39 RISE=15 TARG v(k05_orx) VAL=1.56 RISE=15
meas tran tp_k06 TRIG v(k06_omac) VAL=0.975 RISE=5 TARG v(k06_omac) VAL=0.975 RISE=25
meas tran tq_k06 TRIG v(k06_orx) VAL=0.975 RISE=5 TARG v(k06_orx) VAL=0.975 RISE=25
meas tran hi_k06 TRIG v(k06_omac) VAL=0.975 RISE=15 TARG v(k06_omac) VAL=0.975 FALL=15
meas tran hx_k06 TRIG v(k06_orx) VAL=0.975 RISE=15 TARG v(k06_orx) VAL=0.975 FALL=15
meas tran dr_k06 TRIG v(k06_omac) VAL=0.975 RISE=15 TARG v(k06_orx) VAL=0.975 RISE=15
meas tran df_k06 TRIG v(k06_omac) VAL=0.975 FALL=15 TARG v(k06_orx) VAL=0.975 FALL=15
meas tran sm_k06 TRIG v(k06_omac) VAL=0.39 RISE=15 TARG v(k06_omac) VAL=1.56 RISE=15
meas tran sr_k06 TRIG v(k06_orx) VAL=0.39 RISE=15 TARG v(k06_orx) VAL=1.56 RISE=15
meas tran tp_k07 TRIG v(k07_omac) VAL=0.975 RISE=5 TARG v(k07_omac) VAL=0.975 RISE=25
meas tran tq_k07 TRIG v(k07_orx) VAL=0.975 RISE=5 TARG v(k07_orx) VAL=0.975 RISE=25
meas tran hi_k07 TRIG v(k07_omac) VAL=0.975 RISE=15 TARG v(k07_omac) VAL=0.975 FALL=15
meas tran hx_k07 TRIG v(k07_orx) VAL=0.975 RISE=15 TARG v(k07_orx) VAL=0.975 FALL=15
meas tran dr_k07 TRIG v(k07_omac) VAL=0.975 RISE=15 TARG v(k07_orx) VAL=0.975 RISE=15
meas tran df_k07 TRIG v(k07_omac) VAL=0.975 FALL=15 TARG v(k07_orx) VAL=0.975 FALL=15
meas tran sm_k07 TRIG v(k07_omac) VAL=0.39 RISE=15 TARG v(k07_omac) VAL=1.56 RISE=15
meas tran sr_k07 TRIG v(k07_orx) VAL=0.39 RISE=15 TARG v(k07_orx) VAL=1.56 RISE=15
meas tran tp_k08 TRIG v(k08_omac) VAL=0.975 RISE=5 TARG v(k08_omac) VAL=0.975 RISE=25
meas tran tq_k08 TRIG v(k08_orx) VAL=0.975 RISE=5 TARG v(k08_orx) VAL=0.975 RISE=25
meas tran hi_k08 TRIG v(k08_omac) VAL=0.975 RISE=15 TARG v(k08_omac) VAL=0.975 FALL=15
meas tran hx_k08 TRIG v(k08_orx) VAL=0.975 RISE=15 TARG v(k08_orx) VAL=0.975 FALL=15
meas tran dr_k08 TRIG v(k08_omac) VAL=0.975 RISE=15 TARG v(k08_orx) VAL=0.975 RISE=15
meas tran df_k08 TRIG v(k08_omac) VAL=0.975 FALL=15 TARG v(k08_orx) VAL=0.975 FALL=15
meas tran sm_k08 TRIG v(k08_omac) VAL=0.39 RISE=15 TARG v(k08_omac) VAL=1.56 RISE=15
meas tran sr_k08 TRIG v(k08_orx) VAL=0.39 RISE=15 TARG v(k08_orx) VAL=1.56 RISE=15
meas tran tp_k09 TRIG v(k09_omac) VAL=0.975 RISE=5 TARG v(k09_omac) VAL=0.975 RISE=25
meas tran tq_k09 TRIG v(k09_orx) VAL=0.975 RISE=5 TARG v(k09_orx) VAL=0.975 RISE=25
meas tran hi_k09 TRIG v(k09_omac) VAL=0.975 RISE=15 TARG v(k09_omac) VAL=0.975 FALL=15
meas tran hx_k09 TRIG v(k09_orx) VAL=0.975 RISE=15 TARG v(k09_orx) VAL=0.975 FALL=15
meas tran dr_k09 TRIG v(k09_omac) VAL=0.975 RISE=15 TARG v(k09_orx) VAL=0.975 RISE=15
meas tran df_k09 TRIG v(k09_omac) VAL=0.975 FALL=15 TARG v(k09_orx) VAL=0.975 FALL=15
meas tran sm_k09 TRIG v(k09_omac) VAL=0.39 RISE=15 TARG v(k09_omac) VAL=1.56 RISE=15
meas tran sr_k09 TRIG v(k09_orx) VAL=0.39 RISE=15 TARG v(k09_orx) VAL=1.56 RISE=15
meas tran tp_k10 TRIG v(k10_omac) VAL=0.975 RISE=5 TARG v(k10_omac) VAL=0.975 RISE=25
meas tran tq_k10 TRIG v(k10_orx) VAL=0.975 RISE=5 TARG v(k10_orx) VAL=0.975 RISE=25
meas tran hi_k10 TRIG v(k10_omac) VAL=0.975 RISE=15 TARG v(k10_omac) VAL=0.975 FALL=15
meas tran hx_k10 TRIG v(k10_orx) VAL=0.975 RISE=15 TARG v(k10_orx) VAL=0.975 FALL=15
meas tran dr_k10 TRIG v(k10_omac) VAL=0.975 RISE=15 TARG v(k10_orx) VAL=0.975 RISE=15
meas tran df_k10 TRIG v(k10_omac) VAL=0.975 FALL=15 TARG v(k10_orx) VAL=0.975 FALL=15
meas tran sm_k10 TRIG v(k10_omac) VAL=0.39 RISE=15 TARG v(k10_omac) VAL=1.56 RISE=15
meas tran sr_k10 TRIG v(k10_orx) VAL=0.39 RISE=15 TARG v(k10_orx) VAL=1.56 RISE=15
meas tran tp_k11 TRIG v(k11_omac) VAL=0.975 RISE=5 TARG v(k11_omac) VAL=0.975 RISE=25
meas tran tq_k11 TRIG v(k11_orx) VAL=0.975 RISE=5 TARG v(k11_orx) VAL=0.975 RISE=25
meas tran hi_k11 TRIG v(k11_omac) VAL=0.975 RISE=15 TARG v(k11_omac) VAL=0.975 FALL=15
meas tran hx_k11 TRIG v(k11_orx) VAL=0.975 RISE=15 TARG v(k11_orx) VAL=0.975 FALL=15
meas tran dr_k11 TRIG v(k11_omac) VAL=0.975 RISE=15 TARG v(k11_orx) VAL=0.975 RISE=15
meas tran df_k11 TRIG v(k11_omac) VAL=0.975 FALL=15 TARG v(k11_orx) VAL=0.975 FALL=15
meas tran sm_k11 TRIG v(k11_omac) VAL=0.39 RISE=15 TARG v(k11_omac) VAL=1.56 RISE=15
meas tran sr_k11 TRIG v(k11_orx) VAL=0.39 RISE=15 TARG v(k11_orx) VAL=1.56 RISE=15
meas tran tp_k12 TRIG v(k12_omac) VAL=0.975 RISE=5 TARG v(k12_omac) VAL=0.975 RISE=25
meas tran tq_k12 TRIG v(k12_orx) VAL=0.975 RISE=5 TARG v(k12_orx) VAL=0.975 RISE=25
meas tran hi_k12 TRIG v(k12_omac) VAL=0.975 RISE=15 TARG v(k12_omac) VAL=0.975 FALL=15
meas tran hx_k12 TRIG v(k12_orx) VAL=0.975 RISE=15 TARG v(k12_orx) VAL=0.975 FALL=15
meas tran dr_k12 TRIG v(k12_omac) VAL=0.975 RISE=15 TARG v(k12_orx) VAL=0.975 RISE=15
meas tran df_k12 TRIG v(k12_omac) VAL=0.975 FALL=15 TARG v(k12_orx) VAL=0.975 FALL=15
meas tran sm_k12 TRIG v(k12_omac) VAL=0.39 RISE=15 TARG v(k12_omac) VAL=1.56 RISE=15
meas tran sr_k12 TRIG v(k12_orx) VAL=0.39 RISE=15 TARG v(k12_orx) VAL=1.56 RISE=15
meas tran tp_k13 TRIG v(k13_omac) VAL=0.975 RISE=5 TARG v(k13_omac) VAL=0.975 RISE=25
meas tran tq_k13 TRIG v(k13_orx) VAL=0.975 RISE=5 TARG v(k13_orx) VAL=0.975 RISE=25
meas tran hi_k13 TRIG v(k13_omac) VAL=0.975 RISE=15 TARG v(k13_omac) VAL=0.975 FALL=15
meas tran hx_k13 TRIG v(k13_orx) VAL=0.975 RISE=15 TARG v(k13_orx) VAL=0.975 FALL=15
meas tran dr_k13 TRIG v(k13_omac) VAL=0.975 RISE=15 TARG v(k13_orx) VAL=0.975 RISE=15
meas tran df_k13 TRIG v(k13_omac) VAL=0.975 FALL=15 TARG v(k13_orx) VAL=0.975 FALL=15
meas tran sm_k13 TRIG v(k13_omac) VAL=0.39 RISE=15 TARG v(k13_omac) VAL=1.56 RISE=15
meas tran sr_k13 TRIG v(k13_orx) VAL=0.39 RISE=15 TARG v(k13_orx) VAL=1.56 RISE=15
meas tran tp_k14 TRIG v(k14_omac) VAL=0.975 RISE=5 TARG v(k14_omac) VAL=0.975 RISE=25
meas tran tq_k14 TRIG v(k14_orx) VAL=0.975 RISE=5 TARG v(k14_orx) VAL=0.975 RISE=25
meas tran hi_k14 TRIG v(k14_omac) VAL=0.975 RISE=15 TARG v(k14_omac) VAL=0.975 FALL=15
meas tran hx_k14 TRIG v(k14_orx) VAL=0.975 RISE=15 TARG v(k14_orx) VAL=0.975 FALL=15
meas tran dr_k14 TRIG v(k14_omac) VAL=0.975 RISE=15 TARG v(k14_orx) VAL=0.975 RISE=15
meas tran df_k14 TRIG v(k14_omac) VAL=0.975 FALL=15 TARG v(k14_orx) VAL=0.975 FALL=15
meas tran sm_k14 TRIG v(k14_omac) VAL=0.39 RISE=15 TARG v(k14_omac) VAL=1.56 RISE=15
meas tran sr_k14 TRIG v(k14_orx) VAL=0.39 RISE=15 TARG v(k14_orx) VAL=1.56 RISE=15
meas tran tp_k15 TRIG v(k15_omac) VAL=0.975 RISE=5 TARG v(k15_omac) VAL=0.975 RISE=25
meas tran tq_k15 TRIG v(k15_orx) VAL=0.975 RISE=5 TARG v(k15_orx) VAL=0.975 RISE=25
meas tran hi_k15 TRIG v(k15_omac) VAL=0.975 RISE=15 TARG v(k15_omac) VAL=0.975 FALL=15
meas tran hx_k15 TRIG v(k15_orx) VAL=0.975 RISE=15 TARG v(k15_orx) VAL=0.975 FALL=15
meas tran dr_k15 TRIG v(k15_omac) VAL=0.975 RISE=15 TARG v(k15_orx) VAL=0.975 RISE=15
meas tran df_k15 TRIG v(k15_omac) VAL=0.975 FALL=15 TARG v(k15_orx) VAL=0.975 FALL=15
meas tran sm_k15 TRIG v(k15_omac) VAL=0.39 RISE=15 TARG v(k15_omac) VAL=1.56 RISE=15
meas tran sr_k15 TRIG v(k15_orx) VAL=0.39 RISE=15 TARG v(k15_orx) VAL=1.56 RISE=15
let f_c = 20 / tp_c
let f_r = 20 / tp_r
let f_k00 = 20 / tp_k00
let f_k01 = 20 / tp_k01
let f_k02 = 20 / tp_k02
let f_k03 = 20 / tp_k03
let f_k04 = 20 / tp_k04
let f_k05 = 20 / tp_k05
let f_k06 = 20 / tp_k06
let f_k07 = 20 / tp_k07
let f_k08 = 20 / tp_k08
let f_k09 = 20 / tp_k09
let f_k10 = 20 / tp_k10
let f_k11 = 20 / tp_k11
let f_k12 = 20 / tp_k12
let f_k13 = 20 / tp_k13
let f_k14 = 20 / tp_k14
let f_k15 = 20 / tp_k15
print f_c
print f_r
print f_k00
print f_k01
print f_k02
print f_k03
print f_k04
print f_k05
print f_k06
print f_k07
print f_k08
print f_k09
print f_k10
print f_k11
print f_k12
print f_k13
print f_k14
print f_k15
quit
.endc
.end
