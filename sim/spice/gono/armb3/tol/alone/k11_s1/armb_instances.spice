* Arm B, one ring alone: instance 11 with its routes, from armb3/armb_instances.spice
* auto-generated by gen_instance_decks.py
.lib "/home/pc/pdks/sky130A/libs.tech/ngspice/sky130.lib.spice" tt
.include "/home/pc/pdks/sky130A/libs.ref/sky130_fd_sc_hd/spice/sky130_fd_sc_hd.spice"
.param SUPPLY=1.8
Vdd VPWR 0 {SUPPLY}
Vone ONE 0 1.8
Ven EN 0 PULSE(0 1.8 2n 50p 50p 1 2)

* --- instance 11: u_rob11, enable from _334_.X, output into _461_.B2 ---
Xk11_drv EN ONE ONE 0 0 VPWR VPWR k11_edrv sky130_fd_sc_hd__and3_2
Rk11_e0 k11_edrv k11_epin 44.8268
Ck11_eg0 k11_epin 0 1.438830e-15
Ck11_eg1 k11_edrv 0 1.438830e-15
Ck11_ex0 k11_epin 0 8.660630e-17
Ck11_ex1 k11_epin 0 1.246520e-15
Xk11_dlyin k11_epin 0 0 VPWR VPWR k11_net1 sky130_fd_sc_hd__clkdlybuf4s25_1
Xk11_nand k11_net1 k11_n30 0 0 VPWR VPWR k11_n0 sky130_fd_sc_hd__nand2_1
Xk11_inv1 k11_n0 0 0 VPWR VPWR k11_n1 sky130_fd_sc_hd__inv_1
Xk11_inv2 k11_n1 0 0 VPWR VPWR k11_n2 sky130_fd_sc_hd__inv_1
Xk11_inv3 k11_n2 0 0 VPWR VPWR k11_n3 sky130_fd_sc_hd__inv_1
Xk11_inv4 k11_n3 0 0 VPWR VPWR k11_n4 sky130_fd_sc_hd__inv_1
Xk11_inv5 k11_n4 0 0 VPWR VPWR k11_n5 sky130_fd_sc_hd__inv_1
Xk11_inv6 k11_n5 0 0 VPWR VPWR k11_n6 sky130_fd_sc_hd__inv_1
Xk11_inv7 k11_n6 0 0 VPWR VPWR k11_n7 sky130_fd_sc_hd__inv_1
Xk11_inv8 k11_n7 0 0 VPWR VPWR k11_n8 sky130_fd_sc_hd__inv_1
Xk11_inv9 k11_n8 0 0 VPWR VPWR k11_n9 sky130_fd_sc_hd__inv_1
Xk11_inv10 k11_n9 0 0 VPWR VPWR k11_n10 sky130_fd_sc_hd__inv_1
Xk11_inv11 k11_n10 0 0 VPWR VPWR k11_n11 sky130_fd_sc_hd__inv_1
Xk11_inv12 k11_n11 0 0 VPWR VPWR k11_n12 sky130_fd_sc_hd__inv_1
Xk11_inv13 k11_n12 0 0 VPWR VPWR k11_n13 sky130_fd_sc_hd__inv_1
Xk11_inv14 k11_n13 0 0 VPWR VPWR k11_n14 sky130_fd_sc_hd__inv_1
Xk11_inv15 k11_n14 0 0 VPWR VPWR k11_n15 sky130_fd_sc_hd__inv_1
Xk11_inv16 k11_n15 0 0 VPWR VPWR k11_n16 sky130_fd_sc_hd__inv_1
Xk11_inv17 k11_n16 0 0 VPWR VPWR k11_n17 sky130_fd_sc_hd__inv_1
Xk11_inv18 k11_n17 0 0 VPWR VPWR k11_n18 sky130_fd_sc_hd__inv_1
Xk11_inv19 k11_n18 0 0 VPWR VPWR k11_n19 sky130_fd_sc_hd__inv_1
Xk11_inv20 k11_n19 0 0 VPWR VPWR k11_n20 sky130_fd_sc_hd__inv_1
Xk11_inv21 k11_n20 0 0 VPWR VPWR k11_n21 sky130_fd_sc_hd__inv_1
Xk11_inv22 k11_n21 0 0 VPWR VPWR k11_n22 sky130_fd_sc_hd__inv_1
Xk11_inv23 k11_n22 0 0 VPWR VPWR k11_n23 sky130_fd_sc_hd__inv_1
Xk11_inv24 k11_n23 0 0 VPWR VPWR k11_n24 sky130_fd_sc_hd__inv_1
Xk11_inv25 k11_n24 0 0 VPWR VPWR k11_n25 sky130_fd_sc_hd__inv_1
Xk11_inv26 k11_n25 0 0 VPWR VPWR k11_n26 sky130_fd_sc_hd__inv_1
Xk11_inv27 k11_n26 0 0 VPWR VPWR k11_n27 sky130_fd_sc_hd__inv_1
Xk11_inv28 k11_n27 0 0 VPWR VPWR k11_n28 sky130_fd_sc_hd__inv_1
Xk11_inv29 k11_n28 0 0 VPWR VPWR k11_n29 sky130_fd_sc_hd__inv_1
Xk11_inv30 k11_n29 0 0 VPWR VPWR k11_n30 sky130_fd_sc_hd__inv_1
Xk11_buf k11_n15 0 0 VPWR VPWR k11_net2 sky130_fd_sc_hd__buf_1
Xk11_dlyout k11_net2 0 0 VPWR VPWR k11_omac sky130_fd_sc_hd__clkdlybuf4s25_1
Ck11_n0 k11_n0 0 3.068490e-16
Ck11_n1 k11_n1 0 2.255910e-16
Ck11_n2 k11_n2 0 1.067930e-16
Ck11_n3 k11_n3 0 6.592350e-16
Ck11_n4 k11_n4 0 4.933900e-16
Ck11_n5 k11_n5 0 2.255700e-16
Ck11_n6 k11_n6 0 5.757220e-16
Ck11_n7 k11_n7 0 5.002390e-16
Ck11_n8 k11_n8 0 1.628300e-16
Ck11_n9 k11_n9 0 3.187680e-16
Ck11_n10 k11_n10 0 1.067930e-16
Ck11_n11 k11_n11 0 1.067930e-16
Ck11_n12 k11_n12 0 1.233470e-16
Ck11_n13 k11_n13 0 1.067930e-16
Ck11_n14 k11_n14 0 1.231760e-16
Ck11_n15 k11_n15 0 5.925330e-16
Ck11_n16 k11_n16 0 2.188230e-16
Ck11_n17 k11_n17 0 5.031700e-16
Ck11_n18 k11_n18 0 7.865940e-16
Ck11_n19 k11_n19 0 6.291400e-16
Ck11_n20 k11_n20 0 1.820890e-16
Ck11_n21 k11_n21 0 4.232880e-16
Ck11_n22 k11_n22 0 1.178430e-16
Ck11_n23 k11_n23 0 1.629830e-16
Ck11_n24 k11_n24 0 8.774660e-16
Ck11_n25 k11_n25 0 1.574940e-16
Ck11_n26 k11_n26 0 7.696420e-16
Ck11_n27 k11_n27 0 4.887020e-16
Ck11_n28 k11_n28 0 2.381970e-16
Ck11_n29 k11_n29 0 1.081190e-16
Ck11_n30 k11_n30 0 6.156450e-16
Ck11_net1 k11_net1 0 5.083940e-16
Ck11_net2 k11_net2 0 7.365850e-16
Ck11_en k11_epin 0 1.128140e-15
Ck11_out k11_omac 0 1.942570e-15
Rk11_o0 k11_omac k11_o331_11 44.4196
Rk11_o1 k11_o331_11 k11_orx 25.8937
Ck11_og0 k11_orx 0 4.101930e-16
Ck11_og1 k11_omac 0 1.439630e-15
Ck11_og2 k11_o331_11 0 1.849820e-15
Ck11_ox0 k11_orx 0 4.652570e-16
Ck11_ox1 k11_orx 0 2.281250e-16
Ck11_ox2 k11_orx 0 3.566490e-16
Ck11_ox3 k11_o331_11 0 1.433850e-15
Ck11_ox4 k11_orx 0 9.547980e-18
Xk11_rcv 0 0 ONE k11_orx 0 0 0 VPWR VPWR k11_rxout sky130_fd_sc_hd__a221o_2
Ck11_rxout k11_rxout 0 4.011830e-15

.save v(k11_omac) v(k11_orx)
.options reltol=1e-05
.tran 1p 80n 0 0.25p
.control
run
meas tran tp_k11 TRIG v(k11_omac) VAL=0.9 RISE=5 TARG v(k11_omac) VAL=0.9 RISE=25
meas tran tq_k11 TRIG v(k11_orx) VAL=0.9 RISE=5 TARG v(k11_orx) VAL=0.9 RISE=25
meas tran hi_k11 TRIG v(k11_omac) VAL=0.9 RISE=15 TARG v(k11_omac) VAL=0.9 FALL=15
meas tran hx_k11 TRIG v(k11_orx) VAL=0.9 RISE=15 TARG v(k11_orx) VAL=0.9 FALL=15
meas tran dr_k11 TRIG v(k11_omac) VAL=0.9 RISE=15 TARG v(k11_orx) VAL=0.9 RISE=15
meas tran df_k11 TRIG v(k11_omac) VAL=0.9 FALL=15 TARG v(k11_orx) VAL=0.9 FALL=15
meas tran sm_k11 TRIG v(k11_omac) VAL=0.36 RISE=15 TARG v(k11_omac) VAL=1.44 RISE=15
meas tran sr_k11 TRIG v(k11_orx) VAL=0.36 RISE=15 TARG v(k11_orx) VAL=1.44 RISE=15
let f_k11 = 20 / tp_k11
print f_k11
wrdata armb_wave.txt v(k11_omac)
quit
.endc
.end
