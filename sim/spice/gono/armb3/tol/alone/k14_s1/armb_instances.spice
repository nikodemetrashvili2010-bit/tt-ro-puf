* Arm B, one ring alone: instance 14 with its routes, from armb3/armb_instances.spice
* auto-generated by gen_instance_decks.py
.lib "/home/pc/pdks/sky130A/libs.tech/ngspice/sky130.lib.spice" tt
.include "/home/pc/pdks/sky130A/libs.ref/sky130_fd_sc_hd/spice/sky130_fd_sc_hd.spice"
.param SUPPLY=1.8
Vdd VPWR 0 {SUPPLY}
Vone ONE 0 1.8
Ven EN 0 PULSE(0 1.8 2n 50p 50p 1 2)

* --- instance 14: u_rob14, enable from _337_.X, output into _465_.B2 ---
Xk14_drv EN ONE ONE 0 0 VPWR VPWR k14_edrv sky130_fd_sc_hd__and3_2
Rk14_e0 k14_edrv k14_epin 38.6932
Ck14_eg0 k14_epin 0 2.535130e-15
Ck14_eg1 k14_edrv 0 2.535130e-15
Ck14_ex0 k14_epin 0 2.231120e-17
Ck14_ex1 k14_epin 0 2.278080e-16
Ck14_ex2 k14_epin 0 1.350120e-16
Ck14_ex3 k14_epin 0 1.455860e-16
Ck14_ex4 k14_epin 0 3.782700e-17
Ck14_ex5 k14_epin 0 4.984220e-17
Ck14_ex6 k14_epin 0 6.336240e-16
Ck14_ex7 k14_epin 0 8.124620e-16
Ck14_ex8 k14_epin 0 2.982970e-16
Ck14_ex9 k14_epin 0 6.956700e-16
Ck14_ex10 k14_epin 0 7.033720e-16
Ck14_ex11 k14_epin 0 6.258900e-18
Xk14_dlyin k14_epin 0 0 VPWR VPWR k14_net1 sky130_fd_sc_hd__clkdlybuf4s25_1
Xk14_nand k14_net1 k14_n30 0 0 VPWR VPWR k14_n0 sky130_fd_sc_hd__nand2_1
Xk14_inv1 k14_n0 0 0 VPWR VPWR k14_n1 sky130_fd_sc_hd__inv_1
Xk14_inv2 k14_n1 0 0 VPWR VPWR k14_n2 sky130_fd_sc_hd__inv_1
Xk14_inv3 k14_n2 0 0 VPWR VPWR k14_n3 sky130_fd_sc_hd__inv_1
Xk14_inv4 k14_n3 0 0 VPWR VPWR k14_n4 sky130_fd_sc_hd__inv_1
Xk14_inv5 k14_n4 0 0 VPWR VPWR k14_n5 sky130_fd_sc_hd__inv_1
Xk14_inv6 k14_n5 0 0 VPWR VPWR k14_n6 sky130_fd_sc_hd__inv_1
Xk14_inv7 k14_n6 0 0 VPWR VPWR k14_n7 sky130_fd_sc_hd__inv_1
Xk14_inv8 k14_n7 0 0 VPWR VPWR k14_n8 sky130_fd_sc_hd__inv_1
Xk14_inv9 k14_n8 0 0 VPWR VPWR k14_n9 sky130_fd_sc_hd__inv_1
Xk14_inv10 k14_n9 0 0 VPWR VPWR k14_n10 sky130_fd_sc_hd__inv_1
Xk14_inv11 k14_n10 0 0 VPWR VPWR k14_n11 sky130_fd_sc_hd__inv_1
Xk14_inv12 k14_n11 0 0 VPWR VPWR k14_n12 sky130_fd_sc_hd__inv_1
Xk14_inv13 k14_n12 0 0 VPWR VPWR k14_n13 sky130_fd_sc_hd__inv_1
Xk14_inv14 k14_n13 0 0 VPWR VPWR k14_n14 sky130_fd_sc_hd__inv_1
Xk14_inv15 k14_n14 0 0 VPWR VPWR k14_n15 sky130_fd_sc_hd__inv_1
Xk14_inv16 k14_n15 0 0 VPWR VPWR k14_n16 sky130_fd_sc_hd__inv_1
Xk14_inv17 k14_n16 0 0 VPWR VPWR k14_n17 sky130_fd_sc_hd__inv_1
Xk14_inv18 k14_n17 0 0 VPWR VPWR k14_n18 sky130_fd_sc_hd__inv_1
Xk14_inv19 k14_n18 0 0 VPWR VPWR k14_n19 sky130_fd_sc_hd__inv_1
Xk14_inv20 k14_n19 0 0 VPWR VPWR k14_n20 sky130_fd_sc_hd__inv_1
Xk14_inv21 k14_n20 0 0 VPWR VPWR k14_n21 sky130_fd_sc_hd__inv_1
Xk14_inv22 k14_n21 0 0 VPWR VPWR k14_n22 sky130_fd_sc_hd__inv_1
Xk14_inv23 k14_n22 0 0 VPWR VPWR k14_n23 sky130_fd_sc_hd__inv_1
Xk14_inv24 k14_n23 0 0 VPWR VPWR k14_n24 sky130_fd_sc_hd__inv_1
Xk14_inv25 k14_n24 0 0 VPWR VPWR k14_n25 sky130_fd_sc_hd__inv_1
Xk14_inv26 k14_n25 0 0 VPWR VPWR k14_n26 sky130_fd_sc_hd__inv_1
Xk14_inv27 k14_n26 0 0 VPWR VPWR k14_n27 sky130_fd_sc_hd__inv_1
Xk14_inv28 k14_n27 0 0 VPWR VPWR k14_n28 sky130_fd_sc_hd__inv_1
Xk14_inv29 k14_n28 0 0 VPWR VPWR k14_n29 sky130_fd_sc_hd__inv_1
Xk14_inv30 k14_n29 0 0 VPWR VPWR k14_n30 sky130_fd_sc_hd__inv_1
Xk14_buf k14_n15 0 0 VPWR VPWR k14_net2 sky130_fd_sc_hd__buf_1
Xk14_dlyout k14_net2 0 0 VPWR VPWR k14_omac sky130_fd_sc_hd__clkdlybuf4s25_1
Ck14_n0 k14_n0 0 3.068490e-16
Ck14_n1 k14_n1 0 2.255910e-16
Ck14_n2 k14_n2 0 1.067930e-16
Ck14_n3 k14_n3 0 6.592350e-16
Ck14_n4 k14_n4 0 4.933900e-16
Ck14_n5 k14_n5 0 2.255700e-16
Ck14_n6 k14_n6 0 5.757220e-16
Ck14_n7 k14_n7 0 5.002390e-16
Ck14_n8 k14_n8 0 1.628300e-16
Ck14_n9 k14_n9 0 3.187680e-16
Ck14_n10 k14_n10 0 1.067930e-16
Ck14_n11 k14_n11 0 1.067930e-16
Ck14_n12 k14_n12 0 1.233470e-16
Ck14_n13 k14_n13 0 1.067930e-16
Ck14_n14 k14_n14 0 1.231760e-16
Ck14_n15 k14_n15 0 5.925330e-16
Ck14_n16 k14_n16 0 2.188230e-16
Ck14_n17 k14_n17 0 5.031700e-16
Ck14_n18 k14_n18 0 7.865940e-16
Ck14_n19 k14_n19 0 6.291400e-16
Ck14_n20 k14_n20 0 1.820890e-16
Ck14_n21 k14_n21 0 4.232880e-16
Ck14_n22 k14_n22 0 1.178430e-16
Ck14_n23 k14_n23 0 1.629830e-16
Ck14_n24 k14_n24 0 8.774660e-16
Ck14_n25 k14_n25 0 1.574940e-16
Ck14_n26 k14_n26 0 7.696420e-16
Ck14_n27 k14_n27 0 4.887020e-16
Ck14_n28 k14_n28 0 2.381970e-16
Ck14_n29 k14_n29 0 1.081190e-16
Ck14_n30 k14_n30 0 6.156450e-16
Ck14_net1 k14_net1 0 5.083940e-16
Ck14_net2 k14_net2 0 7.365850e-16
Ck14_en k14_epin 0 1.128140e-15
Ck14_out k14_omac 0 1.942570e-15
Rk14_o0 k14_omac k14_orx 28.0471
Ck14_og0 k14_orx 0 5.546800e-16
Ck14_og1 k14_omac 0 5.546800e-16
Ck14_ox0 k14_orx 0 9.862100e-17
Ck14_ox1 k14_orx 0 1.202650e-16
Ck14_ox2 k14_orx 0 4.839710e-16
Ck14_ox3 k14_orx 0 3.108850e-17
Ck14_ox4 k14_orx 0 5.257740e-17
Ck14_ox5 k14_orx 0 1.702430e-16
Ck14_ox6 k14_orx 0 1.881750e-17
Ck14_ox7 k14_orx 0 3.476410e-18
Xk14_rcv 0 0 ONE k14_orx 0 0 VPWR VPWR k14_rxout sky130_fd_sc_hd__a22o_2
Ck14_rxout k14_rxout 0 1.104710e-14

.save v(k14_omac) v(k14_orx)
.options reltol=1e-05
.tran 1p 80n 0 0.25p
.control
run
meas tran tp_k14 TRIG v(k14_omac) VAL=0.9 RISE=5 TARG v(k14_omac) VAL=0.9 RISE=25
meas tran tq_k14 TRIG v(k14_orx) VAL=0.9 RISE=5 TARG v(k14_orx) VAL=0.9 RISE=25
meas tran hi_k14 TRIG v(k14_omac) VAL=0.9 RISE=15 TARG v(k14_omac) VAL=0.9 FALL=15
meas tran hx_k14 TRIG v(k14_orx) VAL=0.9 RISE=15 TARG v(k14_orx) VAL=0.9 FALL=15
meas tran dr_k14 TRIG v(k14_omac) VAL=0.9 RISE=15 TARG v(k14_orx) VAL=0.9 RISE=15
meas tran df_k14 TRIG v(k14_omac) VAL=0.9 FALL=15 TARG v(k14_orx) VAL=0.9 FALL=15
meas tran sm_k14 TRIG v(k14_omac) VAL=0.36 RISE=15 TARG v(k14_omac) VAL=1.44 RISE=15
meas tran sr_k14 TRIG v(k14_orx) VAL=0.36 RISE=15 TARG v(k14_orx) VAL=1.44 RISE=15
let f_k14 = 20 / tp_k14
print f_k14
wrdata armb_wave.txt v(k14_omac)
quit
.endc
.end
