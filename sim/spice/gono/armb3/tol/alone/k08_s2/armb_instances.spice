* Arm B, one ring alone: instance 8 with its routes, from armb3/armb_instances.spice
* auto-generated by gen_instance_decks.py
.lib "/home/pc/pdks/sky130A/libs.tech/ngspice/sky130.lib.spice" tt
.include "/home/pc/pdks/sky130A/libs.ref/sky130_fd_sc_hd/spice/sky130_fd_sc_hd.spice"
.param SUPPLY=1.8
Vdd VPWR 0 {SUPPLY}
Vone ONE 0 1.8
Ven EN 0 PULSE(0 1.8 2n 50p 50p 1 2)

* --- instance 8: u_rob8, enable from _331_.X, output into _461_.A1 ---
Xk08_drv EN ONE ONE 0 0 VPWR VPWR k08_edrv sky130_fd_sc_hd__and3_2
Rk08_e0 k08_edrv k08_e327_8 19.6750
Rk08_e1 k08_e327_8 k08_e327_14 49.7500
Rk08_e2 k08_e327_14 k08_epin 11.2679
Ck08_eg0 k08_epin 0 3.356740e-16
Ck08_eg1 k08_edrv 0 7.908540e-17
Ck08_eg2 k08_e327_14 0 2.516680e-15
Ck08_eg3 k08_e327_8 0 2.260090e-15
Ck08_ex0 k08_e327_8 0 3.638370e-16
Ck08_ex1 k08_e327_8 0 1.436250e-16
Ck08_ex2 k08_e327_8 0 6.267140e-16
Ck08_ex3 k08_e327_14 0 5.371650e-16
Xk08_dlyin k08_epin 0 0 VPWR VPWR k08_net1 sky130_fd_sc_hd__clkdlybuf4s25_1
Xk08_nand k08_net1 k08_n30 0 0 VPWR VPWR k08_n0 sky130_fd_sc_hd__nand2_1
Xk08_inv1 k08_n0 0 0 VPWR VPWR k08_n1 sky130_fd_sc_hd__inv_1
Xk08_inv2 k08_n1 0 0 VPWR VPWR k08_n2 sky130_fd_sc_hd__inv_1
Xk08_inv3 k08_n2 0 0 VPWR VPWR k08_n3 sky130_fd_sc_hd__inv_1
Xk08_inv4 k08_n3 0 0 VPWR VPWR k08_n4 sky130_fd_sc_hd__inv_1
Xk08_inv5 k08_n4 0 0 VPWR VPWR k08_n5 sky130_fd_sc_hd__inv_1
Xk08_inv6 k08_n5 0 0 VPWR VPWR k08_n6 sky130_fd_sc_hd__inv_1
Xk08_inv7 k08_n6 0 0 VPWR VPWR k08_n7 sky130_fd_sc_hd__inv_1
Xk08_inv8 k08_n7 0 0 VPWR VPWR k08_n8 sky130_fd_sc_hd__inv_1
Xk08_inv9 k08_n8 0 0 VPWR VPWR k08_n9 sky130_fd_sc_hd__inv_1
Xk08_inv10 k08_n9 0 0 VPWR VPWR k08_n10 sky130_fd_sc_hd__inv_1
Xk08_inv11 k08_n10 0 0 VPWR VPWR k08_n11 sky130_fd_sc_hd__inv_1
Xk08_inv12 k08_n11 0 0 VPWR VPWR k08_n12 sky130_fd_sc_hd__inv_1
Xk08_inv13 k08_n12 0 0 VPWR VPWR k08_n13 sky130_fd_sc_hd__inv_1
Xk08_inv14 k08_n13 0 0 VPWR VPWR k08_n14 sky130_fd_sc_hd__inv_1
Xk08_inv15 k08_n14 0 0 VPWR VPWR k08_n15 sky130_fd_sc_hd__inv_1
Xk08_inv16 k08_n15 0 0 VPWR VPWR k08_n16 sky130_fd_sc_hd__inv_1
Xk08_inv17 k08_n16 0 0 VPWR VPWR k08_n17 sky130_fd_sc_hd__inv_1
Xk08_inv18 k08_n17 0 0 VPWR VPWR k08_n18 sky130_fd_sc_hd__inv_1
Xk08_inv19 k08_n18 0 0 VPWR VPWR k08_n19 sky130_fd_sc_hd__inv_1
Xk08_inv20 k08_n19 0 0 VPWR VPWR k08_n20 sky130_fd_sc_hd__inv_1
Xk08_inv21 k08_n20 0 0 VPWR VPWR k08_n21 sky130_fd_sc_hd__inv_1
Xk08_inv22 k08_n21 0 0 VPWR VPWR k08_n22 sky130_fd_sc_hd__inv_1
Xk08_inv23 k08_n22 0 0 VPWR VPWR k08_n23 sky130_fd_sc_hd__inv_1
Xk08_inv24 k08_n23 0 0 VPWR VPWR k08_n24 sky130_fd_sc_hd__inv_1
Xk08_inv25 k08_n24 0 0 VPWR VPWR k08_n25 sky130_fd_sc_hd__inv_1
Xk08_inv26 k08_n25 0 0 VPWR VPWR k08_n26 sky130_fd_sc_hd__inv_1
Xk08_inv27 k08_n26 0 0 VPWR VPWR k08_n27 sky130_fd_sc_hd__inv_1
Xk08_inv28 k08_n27 0 0 VPWR VPWR k08_n28 sky130_fd_sc_hd__inv_1
Xk08_inv29 k08_n28 0 0 VPWR VPWR k08_n29 sky130_fd_sc_hd__inv_1
Xk08_inv30 k08_n29 0 0 VPWR VPWR k08_n30 sky130_fd_sc_hd__inv_1
Xk08_buf k08_n15 0 0 VPWR VPWR k08_net2 sky130_fd_sc_hd__buf_1
Xk08_dlyout k08_net2 0 0 VPWR VPWR k08_omac sky130_fd_sc_hd__clkdlybuf4s25_1
Ck08_n0 k08_n0 0 3.068490e-16
Ck08_n1 k08_n1 0 2.255910e-16
Ck08_n2 k08_n2 0 1.067930e-16
Ck08_n3 k08_n3 0 6.592350e-16
Ck08_n4 k08_n4 0 4.933900e-16
Ck08_n5 k08_n5 0 2.255700e-16
Ck08_n6 k08_n6 0 5.757220e-16
Ck08_n7 k08_n7 0 5.002390e-16
Ck08_n8 k08_n8 0 1.628300e-16
Ck08_n9 k08_n9 0 3.187680e-16
Ck08_n10 k08_n10 0 1.067930e-16
Ck08_n11 k08_n11 0 1.067930e-16
Ck08_n12 k08_n12 0 1.233470e-16
Ck08_n13 k08_n13 0 1.067930e-16
Ck08_n14 k08_n14 0 1.231760e-16
Ck08_n15 k08_n15 0 5.925330e-16
Ck08_n16 k08_n16 0 2.188230e-16
Ck08_n17 k08_n17 0 5.031700e-16
Ck08_n18 k08_n18 0 7.865940e-16
Ck08_n19 k08_n19 0 6.291400e-16
Ck08_n20 k08_n20 0 1.820890e-16
Ck08_n21 k08_n21 0 4.232880e-16
Ck08_n22 k08_n22 0 1.178430e-16
Ck08_n23 k08_n23 0 1.629830e-16
Ck08_n24 k08_n24 0 8.774660e-16
Ck08_n25 k08_n25 0 1.574940e-16
Ck08_n26 k08_n26 0 7.696420e-16
Ck08_n27 k08_n27 0 4.887020e-16
Ck08_n28 k08_n28 0 2.381970e-16
Ck08_n29 k08_n29 0 1.081190e-16
Ck08_n30 k08_n30 0 6.156450e-16
Ck08_net1 k08_net1 0 5.083940e-16
Ck08_net2 k08_net2 0 7.365850e-16
Ck08_en k08_epin 0 1.128140e-15
Ck08_out k08_omac 0 1.942570e-15
Rk08_o0 k08_omac k08_o343_11 11.4286
Rk08_o1 k08_o343_11 k08_o343_13 195.6250
Rk08_o2 k08_o343_13 k08_orx 25.4071
Ck08_og0 k08_orx 0 2.231690e-16
Ck08_og1 k08_omac 0 3.388000e-16
Ck08_og2 k08_o343_13 0 4.124650e-15
Ck08_og3 k08_o343_11 0 4.240280e-15
Ck08_ox0 k08_orx 0 5.443090e-16
Ck08_ox1 k08_orx 0 9.195220e-17
Ck08_ox2 k08_orx 0 1.344170e-16
Ck08_ox3 k08_o343_13 0 6.998300e-15
Ck08_ox4 k08_o343_13 0 1.729310e-14
Ck08_ox5 k08_o343_13 0 5.407770e-16
Ck08_ox6 k08_o343_13 0 2.013570e-15
Ck08_ox7 k08_o343_13 0 1.829450e-15
Ck08_ox8 k08_o343_13 0 1.350120e-16
Ck08_ox9 k08_o343_13 0 1.203750e-15
Ck08_ox10 k08_o343_13 0 5.678640e-15
Xk08_rcv k08_orx ONE 0 0 0 0 0 VPWR VPWR k08_rxout sky130_fd_sc_hd__a221o_2
Ck08_rxout k08_rxout 0 4.011830e-15

.save v(k08_omac) v(k08_orx)
.options reltol=1e-06
.tran 1p 80n 0 0.1p
.control
run
meas tran tp_k08 TRIG v(k08_omac) VAL=0.9 RISE=5 TARG v(k08_omac) VAL=0.9 RISE=25
meas tran tq_k08 TRIG v(k08_orx) VAL=0.9 RISE=5 TARG v(k08_orx) VAL=0.9 RISE=25
meas tran hi_k08 TRIG v(k08_omac) VAL=0.9 RISE=15 TARG v(k08_omac) VAL=0.9 FALL=15
meas tran hx_k08 TRIG v(k08_orx) VAL=0.9 RISE=15 TARG v(k08_orx) VAL=0.9 FALL=15
meas tran dr_k08 TRIG v(k08_omac) VAL=0.9 RISE=15 TARG v(k08_orx) VAL=0.9 RISE=15
meas tran df_k08 TRIG v(k08_omac) VAL=0.9 FALL=15 TARG v(k08_orx) VAL=0.9 FALL=15
meas tran sm_k08 TRIG v(k08_omac) VAL=0.36 RISE=15 TARG v(k08_omac) VAL=1.44 RISE=15
meas tran sr_k08 TRIG v(k08_orx) VAL=0.36 RISE=15 TARG v(k08_orx) VAL=1.44 RISE=15
let f_k08 = 20 / tp_k08
print f_k08
wrdata armb_wave.txt v(k08_omac)
quit
.endc
.end
