* Arm B, one ring alone: the reference, from armb3/armb_instances.spice
* auto-generated by gen_instance_decks.py
.lib "/home/pc/pdks/sky130A/libs.tech/ngspice/sky130.lib.spice" tt
.include "/home/pc/pdks/sky130A/libs.ref/sky130_fd_sc_hd/spice/sky130_fd_sc_hd.spice"
.param SUPPLY=1.8
Vdd VPWR 0 {SUPPLY}
Vone ONE 0 1.8
Ven EN 0 PULSE(0 1.8 2n 50p 50p 1 2)

* --- reference: macro internal extraction only, nothing external ---
Xr_dlyin EN 0 0 VPWR VPWR r_net1 sky130_fd_sc_hd__clkdlybuf4s25_1
Xr_nand r_net1 r_n30 0 0 VPWR VPWR r_n0 sky130_fd_sc_hd__nand2_1
Xr_inv1 r_n0 0 0 VPWR VPWR r_n1 sky130_fd_sc_hd__inv_1
Xr_inv2 r_n1 0 0 VPWR VPWR r_n2 sky130_fd_sc_hd__inv_1
Xr_inv3 r_n2 0 0 VPWR VPWR r_n3 sky130_fd_sc_hd__inv_1
Xr_inv4 r_n3 0 0 VPWR VPWR r_n4 sky130_fd_sc_hd__inv_1
Xr_inv5 r_n4 0 0 VPWR VPWR r_n5 sky130_fd_sc_hd__inv_1
Xr_inv6 r_n5 0 0 VPWR VPWR r_n6 sky130_fd_sc_hd__inv_1
Xr_inv7 r_n6 0 0 VPWR VPWR r_n7 sky130_fd_sc_hd__inv_1
Xr_inv8 r_n7 0 0 VPWR VPWR r_n8 sky130_fd_sc_hd__inv_1
Xr_inv9 r_n8 0 0 VPWR VPWR r_n9 sky130_fd_sc_hd__inv_1
Xr_inv10 r_n9 0 0 VPWR VPWR r_n10 sky130_fd_sc_hd__inv_1
Xr_inv11 r_n10 0 0 VPWR VPWR r_n11 sky130_fd_sc_hd__inv_1
Xr_inv12 r_n11 0 0 VPWR VPWR r_n12 sky130_fd_sc_hd__inv_1
Xr_inv13 r_n12 0 0 VPWR VPWR r_n13 sky130_fd_sc_hd__inv_1
Xr_inv14 r_n13 0 0 VPWR VPWR r_n14 sky130_fd_sc_hd__inv_1
Xr_inv15 r_n14 0 0 VPWR VPWR r_n15 sky130_fd_sc_hd__inv_1
Xr_inv16 r_n15 0 0 VPWR VPWR r_n16 sky130_fd_sc_hd__inv_1
Xr_inv17 r_n16 0 0 VPWR VPWR r_n17 sky130_fd_sc_hd__inv_1
Xr_inv18 r_n17 0 0 VPWR VPWR r_n18 sky130_fd_sc_hd__inv_1
Xr_inv19 r_n18 0 0 VPWR VPWR r_n19 sky130_fd_sc_hd__inv_1
Xr_inv20 r_n19 0 0 VPWR VPWR r_n20 sky130_fd_sc_hd__inv_1
Xr_inv21 r_n20 0 0 VPWR VPWR r_n21 sky130_fd_sc_hd__inv_1
Xr_inv22 r_n21 0 0 VPWR VPWR r_n22 sky130_fd_sc_hd__inv_1
Xr_inv23 r_n22 0 0 VPWR VPWR r_n23 sky130_fd_sc_hd__inv_1
Xr_inv24 r_n23 0 0 VPWR VPWR r_n24 sky130_fd_sc_hd__inv_1
Xr_inv25 r_n24 0 0 VPWR VPWR r_n25 sky130_fd_sc_hd__inv_1
Xr_inv26 r_n25 0 0 VPWR VPWR r_n26 sky130_fd_sc_hd__inv_1
Xr_inv27 r_n26 0 0 VPWR VPWR r_n27 sky130_fd_sc_hd__inv_1
Xr_inv28 r_n27 0 0 VPWR VPWR r_n28 sky130_fd_sc_hd__inv_1
Xr_inv29 r_n28 0 0 VPWR VPWR r_n29 sky130_fd_sc_hd__inv_1
Xr_inv30 r_n29 0 0 VPWR VPWR r_n30 sky130_fd_sc_hd__inv_1
Xr_buf r_n15 0 0 VPWR VPWR r_net2 sky130_fd_sc_hd__buf_1
Xr_dlyout r_net2 0 0 VPWR VPWR r_out sky130_fd_sc_hd__clkdlybuf4s25_1
Cr_n0 r_n0 0 3.068490e-16
Cr_n1 r_n1 0 2.255910e-16
Cr_n2 r_n2 0 1.067930e-16
Cr_n3 r_n3 0 6.592350e-16
Cr_n4 r_n4 0 4.933900e-16
Cr_n5 r_n5 0 2.255700e-16
Cr_n6 r_n6 0 5.757220e-16
Cr_n7 r_n7 0 5.002390e-16
Cr_n8 r_n8 0 1.628300e-16
Cr_n9 r_n9 0 3.187680e-16
Cr_n10 r_n10 0 1.067930e-16
Cr_n11 r_n11 0 1.067930e-16
Cr_n12 r_n12 0 1.233470e-16
Cr_n13 r_n13 0 1.067930e-16
Cr_n14 r_n14 0 1.231760e-16
Cr_n15 r_n15 0 5.925330e-16
Cr_n16 r_n16 0 2.188230e-16
Cr_n17 r_n17 0 5.031700e-16
Cr_n18 r_n18 0 7.865940e-16
Cr_n19 r_n19 0 6.291400e-16
Cr_n20 r_n20 0 1.820890e-16
Cr_n21 r_n21 0 4.232880e-16
Cr_n22 r_n22 0 1.178430e-16
Cr_n23 r_n23 0 1.629830e-16
Cr_n24 r_n24 0 8.774660e-16
Cr_n25 r_n25 0 1.574940e-16
Cr_n26 r_n26 0 7.696420e-16
Cr_n27 r_n27 0 4.887020e-16
Cr_n28 r_n28 0 2.381970e-16
Cr_n29 r_n29 0 1.081190e-16
Cr_n30 r_n30 0 6.156450e-16
Cr_net1 r_net1 0 5.083940e-16
Cr_net2 r_net2 0 7.365850e-16
Cr_en EN 0 1.128140e-15
Cr_out r_out 0 1.942570e-15

.save v(r_out)
.options reltol=1e-06
.tran 1p 80n 0 0.1p
.control
run
meas tran tp_r TRIG v(r_out) VAL=0.9 RISE=5 TARG v(r_out) VAL=0.9 RISE=25
meas tran hi_r TRIG v(r_out) VAL=0.9 RISE=15 TARG v(r_out) VAL=0.9 FALL=15
let f_r = 20 / tp_r
print f_r
wrdata armb_wave.txt v(r_out)
quit
.endc
.end
