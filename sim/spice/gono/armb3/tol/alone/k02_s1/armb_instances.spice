* Arm B, one ring alone: instance 2 with its routes, from armb3/armb_instances.spice
* auto-generated by gen_instance_decks.py
.lib "/home/pc/pdks/sky130A/libs.tech/ngspice/sky130.lib.spice" tt
.include "/home/pc/pdks/sky130A/libs.ref/sky130_fd_sc_hd/spice/sky130_fd_sc_hd.spice"
.param SUPPLY=1.8
Vdd VPWR 0 {SUPPLY}
Vone ONE 0 1.8
Ven EN 0 PULSE(0 1.8 2n 50p 50p 1 2)

* --- instance 2: u_rob2, enable from _325_.X, output into _467_.B2 ---
Xk02_drv EN ONE ONE 0 0 VPWR VPWR k02_edrv sky130_fd_sc_hd__and3_2
Rk02_e0 k02_edrv k02_epin 39.0726
Ck02_eg0 k02_epin 0 2.678470e-15
Ck02_eg1 k02_edrv 0 2.678470e-15
Ck02_ex0 k02_epin 0 5.257590e-17
Ck02_ex1 k02_epin 0 3.091650e-16
Ck02_ex2 k02_epin 0 1.306070e-17
Xk02_dlyin k02_epin 0 0 VPWR VPWR k02_net1 sky130_fd_sc_hd__clkdlybuf4s25_1
Xk02_nand k02_net1 k02_n30 0 0 VPWR VPWR k02_n0 sky130_fd_sc_hd__nand2_1
Xk02_inv1 k02_n0 0 0 VPWR VPWR k02_n1 sky130_fd_sc_hd__inv_1
Xk02_inv2 k02_n1 0 0 VPWR VPWR k02_n2 sky130_fd_sc_hd__inv_1
Xk02_inv3 k02_n2 0 0 VPWR VPWR k02_n3 sky130_fd_sc_hd__inv_1
Xk02_inv4 k02_n3 0 0 VPWR VPWR k02_n4 sky130_fd_sc_hd__inv_1
Xk02_inv5 k02_n4 0 0 VPWR VPWR k02_n5 sky130_fd_sc_hd__inv_1
Xk02_inv6 k02_n5 0 0 VPWR VPWR k02_n6 sky130_fd_sc_hd__inv_1
Xk02_inv7 k02_n6 0 0 VPWR VPWR k02_n7 sky130_fd_sc_hd__inv_1
Xk02_inv8 k02_n7 0 0 VPWR VPWR k02_n8 sky130_fd_sc_hd__inv_1
Xk02_inv9 k02_n8 0 0 VPWR VPWR k02_n9 sky130_fd_sc_hd__inv_1
Xk02_inv10 k02_n9 0 0 VPWR VPWR k02_n10 sky130_fd_sc_hd__inv_1
Xk02_inv11 k02_n10 0 0 VPWR VPWR k02_n11 sky130_fd_sc_hd__inv_1
Xk02_inv12 k02_n11 0 0 VPWR VPWR k02_n12 sky130_fd_sc_hd__inv_1
Xk02_inv13 k02_n12 0 0 VPWR VPWR k02_n13 sky130_fd_sc_hd__inv_1
Xk02_inv14 k02_n13 0 0 VPWR VPWR k02_n14 sky130_fd_sc_hd__inv_1
Xk02_inv15 k02_n14 0 0 VPWR VPWR k02_n15 sky130_fd_sc_hd__inv_1
Xk02_inv16 k02_n15 0 0 VPWR VPWR k02_n16 sky130_fd_sc_hd__inv_1
Xk02_inv17 k02_n16 0 0 VPWR VPWR k02_n17 sky130_fd_sc_hd__inv_1
Xk02_inv18 k02_n17 0 0 VPWR VPWR k02_n18 sky130_fd_sc_hd__inv_1
Xk02_inv19 k02_n18 0 0 VPWR VPWR k02_n19 sky130_fd_sc_hd__inv_1
Xk02_inv20 k02_n19 0 0 VPWR VPWR k02_n20 sky130_fd_sc_hd__inv_1
Xk02_inv21 k02_n20 0 0 VPWR VPWR k02_n21 sky130_fd_sc_hd__inv_1
Xk02_inv22 k02_n21 0 0 VPWR VPWR k02_n22 sky130_fd_sc_hd__inv_1
Xk02_inv23 k02_n22 0 0 VPWR VPWR k02_n23 sky130_fd_sc_hd__inv_1
Xk02_inv24 k02_n23 0 0 VPWR VPWR k02_n24 sky130_fd_sc_hd__inv_1
Xk02_inv25 k02_n24 0 0 VPWR VPWR k02_n25 sky130_fd_sc_hd__inv_1
Xk02_inv26 k02_n25 0 0 VPWR VPWR k02_n26 sky130_fd_sc_hd__inv_1
Xk02_inv27 k02_n26 0 0 VPWR VPWR k02_n27 sky130_fd_sc_hd__inv_1
Xk02_inv28 k02_n27 0 0 VPWR VPWR k02_n28 sky130_fd_sc_hd__inv_1
Xk02_inv29 k02_n28 0 0 VPWR VPWR k02_n29 sky130_fd_sc_hd__inv_1
Xk02_inv30 k02_n29 0 0 VPWR VPWR k02_n30 sky130_fd_sc_hd__inv_1
Xk02_buf k02_n15 0 0 VPWR VPWR k02_net2 sky130_fd_sc_hd__buf_1
Xk02_dlyout k02_net2 0 0 VPWR VPWR k02_omac sky130_fd_sc_hd__clkdlybuf4s25_1
Ck02_n0 k02_n0 0 3.068490e-16
Ck02_n1 k02_n1 0 2.255910e-16
Ck02_n2 k02_n2 0 1.067930e-16
Ck02_n3 k02_n3 0 6.592350e-16
Ck02_n4 k02_n4 0 4.933900e-16
Ck02_n5 k02_n5 0 2.255700e-16
Ck02_n6 k02_n6 0 5.757220e-16
Ck02_n7 k02_n7 0 5.002390e-16
Ck02_n8 k02_n8 0 1.628300e-16
Ck02_n9 k02_n9 0 3.187680e-16
Ck02_n10 k02_n10 0 1.067930e-16
Ck02_n11 k02_n11 0 1.067930e-16
Ck02_n12 k02_n12 0 1.233470e-16
Ck02_n13 k02_n13 0 1.067930e-16
Ck02_n14 k02_n14 0 1.231760e-16
Ck02_n15 k02_n15 0 5.925330e-16
Ck02_n16 k02_n16 0 2.188230e-16
Ck02_n17 k02_n17 0 5.031700e-16
Ck02_n18 k02_n18 0 7.865940e-16
Ck02_n19 k02_n19 0 6.291400e-16
Ck02_n20 k02_n20 0 1.820890e-16
Ck02_n21 k02_n21 0 4.232880e-16
Ck02_n22 k02_n22 0 1.178430e-16
Ck02_n23 k02_n23 0 1.629830e-16
Ck02_n24 k02_n24 0 8.774660e-16
Ck02_n25 k02_n25 0 1.574940e-16
Ck02_n26 k02_n26 0 7.696420e-16
Ck02_n27 k02_n27 0 4.887020e-16
Ck02_n28 k02_n28 0 2.381970e-16
Ck02_n29 k02_n29 0 1.081190e-16
Ck02_n30 k02_n30 0 6.156450e-16
Ck02_net1 k02_net1 0 5.083940e-16
Ck02_net2 k02_net2 0 7.365850e-16
Ck02_en k02_epin 0 1.128140e-15
Ck02_out k02_omac 0 1.942570e-15
Rk02_o0 k02_omac k02_orx 22.5679
Ck02_og0 k02_orx 0 4.990480e-16
Ck02_og1 k02_omac 0 4.990480e-16
Ck02_ox0 k02_orx 0 1.371970e-16
Ck02_ox1 k02_orx 0 3.086070e-16
Ck02_ox2 k02_orx 0 7.159990e-17
Xk02_rcv 0 0 ONE k02_orx 0 0 VPWR VPWR k02_rxout sky130_fd_sc_hd__a22o_2
Ck02_rxout k02_rxout 0 5.573040e-15

.save v(k02_omac) v(k02_orx)
.options reltol=1e-05
.tran 1p 80n 0 0.25p
.control
run
meas tran tp_k02 TRIG v(k02_omac) VAL=0.9 RISE=5 TARG v(k02_omac) VAL=0.9 RISE=25
meas tran tq_k02 TRIG v(k02_orx) VAL=0.9 RISE=5 TARG v(k02_orx) VAL=0.9 RISE=25
meas tran hi_k02 TRIG v(k02_omac) VAL=0.9 RISE=15 TARG v(k02_omac) VAL=0.9 FALL=15
meas tran hx_k02 TRIG v(k02_orx) VAL=0.9 RISE=15 TARG v(k02_orx) VAL=0.9 FALL=15
meas tran dr_k02 TRIG v(k02_omac) VAL=0.9 RISE=15 TARG v(k02_orx) VAL=0.9 RISE=15
meas tran df_k02 TRIG v(k02_omac) VAL=0.9 FALL=15 TARG v(k02_orx) VAL=0.9 FALL=15
meas tran sm_k02 TRIG v(k02_omac) VAL=0.36 RISE=15 TARG v(k02_omac) VAL=1.44 RISE=15
meas tran sr_k02 TRIG v(k02_orx) VAL=0.36 RISE=15 TARG v(k02_orx) VAL=1.44 RISE=15
let f_k02 = 20 / tp_k02
print f_k02
wrdata armb_wave.txt v(k02_omac)
quit
.endc
.end
