* SILICON go/no-go : PARASITIC (nom SPEF)
* auto-generated by gen_decks.py -- 32 ring oscillators, enable-started
.lib /home/pc/pdks/sky130A/libs.tech/ngspice/sky130.lib.spice tt
.include /home/pc/pdks/sky130A/libs.ref/sky130_fd_sc_hd/spice/sky130_fd_sc_hd.spice
.param SUPPLY=1.8
Vdd VPWR 0 {SUPPLY}
Ven EN 0 PULSE(0 1.8 2n 50p 50p 1 2)

* --- RO 0 ---
X0_nand EN x0_n30 0 0 VPWR VPWR x0_n0 sky130_fd_sc_hd__nand2_1
X0_inv1 x0_n0 0 0 VPWR VPWR x0_n1 sky130_fd_sc_hd__inv_1
X0_inv2 x0_n1 0 0 VPWR VPWR x0_n2 sky130_fd_sc_hd__inv_1
X0_inv3 x0_n2 0 0 VPWR VPWR x0_n3 sky130_fd_sc_hd__inv_1
X0_inv4 x0_n3 0 0 VPWR VPWR x0_n4 sky130_fd_sc_hd__inv_1
X0_inv5 x0_n4 0 0 VPWR VPWR x0_n5 sky130_fd_sc_hd__inv_1
X0_inv6 x0_n5 0 0 VPWR VPWR x0_n6 sky130_fd_sc_hd__inv_1
X0_inv7 x0_n6 0 0 VPWR VPWR x0_n7 sky130_fd_sc_hd__inv_1
X0_inv8 x0_n7 0 0 VPWR VPWR x0_n8 sky130_fd_sc_hd__inv_1
X0_inv9 x0_n8 0 0 VPWR VPWR x0_n9 sky130_fd_sc_hd__inv_1
X0_inv10 x0_n9 0 0 VPWR VPWR x0_n10 sky130_fd_sc_hd__inv_1
X0_inv11 x0_n10 0 0 VPWR VPWR x0_n11 sky130_fd_sc_hd__inv_1
X0_inv12 x0_n11 0 0 VPWR VPWR x0_n12 sky130_fd_sc_hd__inv_1
X0_inv13 x0_n12 0 0 VPWR VPWR x0_n13 sky130_fd_sc_hd__inv_1
X0_inv14 x0_n13 0 0 VPWR VPWR x0_n14 sky130_fd_sc_hd__inv_1
X0_inv15 x0_n14 0 0 VPWR VPWR x0_n15 sky130_fd_sc_hd__inv_1
X0_inv16 x0_n15 0 0 VPWR VPWR x0_n16 sky130_fd_sc_hd__inv_1
X0_inv17 x0_n16 0 0 VPWR VPWR x0_n17 sky130_fd_sc_hd__inv_1
X0_inv18 x0_n17 0 0 VPWR VPWR x0_n18 sky130_fd_sc_hd__inv_1
X0_inv19 x0_n18 0 0 VPWR VPWR x0_n19 sky130_fd_sc_hd__inv_1
X0_inv20 x0_n19 0 0 VPWR VPWR x0_n20 sky130_fd_sc_hd__inv_1
X0_inv21 x0_n20 0 0 VPWR VPWR x0_n21 sky130_fd_sc_hd__inv_1
X0_inv22 x0_n21 0 0 VPWR VPWR x0_n22 sky130_fd_sc_hd__inv_1
X0_inv23 x0_n22 0 0 VPWR VPWR x0_n23 sky130_fd_sc_hd__inv_1
X0_inv24 x0_n23 0 0 VPWR VPWR x0_n24 sky130_fd_sc_hd__inv_1
X0_inv25 x0_n24 0 0 VPWR VPWR x0_n25 sky130_fd_sc_hd__inv_1
X0_inv26 x0_n25 0 0 VPWR VPWR x0_n26 sky130_fd_sc_hd__inv_1
X0_inv27 x0_n26 0 0 VPWR VPWR x0_n27 sky130_fd_sc_hd__inv_1
X0_inv28 x0_n27 0 0 VPWR VPWR x0_n28 sky130_fd_sc_hd__inv_1
X0_inv29 x0_n28 0 0 VPWR VPWR x0_n29 sky130_fd_sc_hd__inv_1
X0_inv30 x0_n29 0 0 VPWR VPWR x0_n30 sky130_fd_sc_hd__inv_1
X0_buf x0_n15 0 0 VPWR VPWR x0_out sky130_fd_sc_hd__buf_1
C0_n0 x0_n0 0 2.752970e-16
C0_n1 x0_n1 0 2.454730e-16
C0_n2 x0_n2 0 6.317100e-16
C0_n3 x0_n3 0 5.481930e-16
C0_n4 x0_n4 0 9.319050e-16
C0_n5 x0_n5 0 1.061260e-15
C0_n6 x0_n6 0 1.640130e-16
C0_n7 x0_n7 0 7.986560e-16
C0_n8 x0_n8 0 9.854740e-16
C0_n9 x0_n9 0 1.696650e-16
C0_n10 x0_n10 0 4.923740e-16
C0_n11 x0_n11 0 5.656180e-16
C0_n12 x0_n12 0 2.396430e-16
C0_n13 x0_n13 0 7.565570e-16
C0_n14 x0_n14 0 5.853490e-16
C0_n15 x0_n15 0 1.259260e-15
C0_n16 x0_n16 0 1.067930e-16
C0_n17 x0_n17 0 6.581350e-16
C0_n18 x0_n18 0 1.980890e-16
C0_n19 x0_n19 0 5.802770e-16
C0_n20 x0_n20 0 5.185700e-16
C0_n21 x0_n21 0 5.852140e-16
C0_n22 x0_n22 0 1.187610e-16
C0_n23 x0_n23 0 5.777830e-16
C0_n24 x0_n24 0 1.067930e-16
C0_n25 x0_n25 0 1.067930e-16
C0_n26 x0_n26 0 1.067930e-16
C0_n27 x0_n27 0 1.067930e-16
C0_n28 x0_n28 0 1.556730e-16
C0_n29 x0_n29 0 5.943110e-16
C0_n30 x0_n30 0 1.859570e-16
C0_out x0_out 0 3.868540e-15
* --- RO 1 ---
X1_nand EN x1_n30 0 0 VPWR VPWR x1_n0 sky130_fd_sc_hd__nand2_1
X1_inv1 x1_n0 0 0 VPWR VPWR x1_n1 sky130_fd_sc_hd__inv_1
X1_inv2 x1_n1 0 0 VPWR VPWR x1_n2 sky130_fd_sc_hd__inv_1
X1_inv3 x1_n2 0 0 VPWR VPWR x1_n3 sky130_fd_sc_hd__inv_1
X1_inv4 x1_n3 0 0 VPWR VPWR x1_n4 sky130_fd_sc_hd__inv_1
X1_inv5 x1_n4 0 0 VPWR VPWR x1_n5 sky130_fd_sc_hd__inv_1
X1_inv6 x1_n5 0 0 VPWR VPWR x1_n6 sky130_fd_sc_hd__inv_1
X1_inv7 x1_n6 0 0 VPWR VPWR x1_n7 sky130_fd_sc_hd__inv_1
X1_inv8 x1_n7 0 0 VPWR VPWR x1_n8 sky130_fd_sc_hd__inv_1
X1_inv9 x1_n8 0 0 VPWR VPWR x1_n9 sky130_fd_sc_hd__inv_1
X1_inv10 x1_n9 0 0 VPWR VPWR x1_n10 sky130_fd_sc_hd__inv_1
X1_inv11 x1_n10 0 0 VPWR VPWR x1_n11 sky130_fd_sc_hd__inv_1
X1_inv12 x1_n11 0 0 VPWR VPWR x1_n12 sky130_fd_sc_hd__inv_1
X1_inv13 x1_n12 0 0 VPWR VPWR x1_n13 sky130_fd_sc_hd__inv_1
X1_inv14 x1_n13 0 0 VPWR VPWR x1_n14 sky130_fd_sc_hd__inv_1
X1_inv15 x1_n14 0 0 VPWR VPWR x1_n15 sky130_fd_sc_hd__inv_1
X1_inv16 x1_n15 0 0 VPWR VPWR x1_n16 sky130_fd_sc_hd__inv_1
X1_inv17 x1_n16 0 0 VPWR VPWR x1_n17 sky130_fd_sc_hd__inv_1
X1_inv18 x1_n17 0 0 VPWR VPWR x1_n18 sky130_fd_sc_hd__inv_1
X1_inv19 x1_n18 0 0 VPWR VPWR x1_n19 sky130_fd_sc_hd__inv_1
X1_inv20 x1_n19 0 0 VPWR VPWR x1_n20 sky130_fd_sc_hd__inv_1
X1_inv21 x1_n20 0 0 VPWR VPWR x1_n21 sky130_fd_sc_hd__inv_1
X1_inv22 x1_n21 0 0 VPWR VPWR x1_n22 sky130_fd_sc_hd__inv_1
X1_inv23 x1_n22 0 0 VPWR VPWR x1_n23 sky130_fd_sc_hd__inv_1
X1_inv24 x1_n23 0 0 VPWR VPWR x1_n24 sky130_fd_sc_hd__inv_1
X1_inv25 x1_n24 0 0 VPWR VPWR x1_n25 sky130_fd_sc_hd__inv_1
X1_inv26 x1_n25 0 0 VPWR VPWR x1_n26 sky130_fd_sc_hd__inv_1
X1_inv27 x1_n26 0 0 VPWR VPWR x1_n27 sky130_fd_sc_hd__inv_1
X1_inv28 x1_n27 0 0 VPWR VPWR x1_n28 sky130_fd_sc_hd__inv_1
X1_inv29 x1_n28 0 0 VPWR VPWR x1_n29 sky130_fd_sc_hd__inv_1
X1_inv30 x1_n29 0 0 VPWR VPWR x1_n30 sky130_fd_sc_hd__inv_1
X1_buf x1_n15 0 0 VPWR VPWR x1_out sky130_fd_sc_hd__buf_1
C1_n0 x1_n0 0 4.917750e-16
C1_n1 x1_n1 0 1.260260e-16
C1_n2 x1_n2 0 1.567170e-16
C1_n3 x1_n3 0 1.110550e-15
C1_n4 x1_n4 0 2.449950e-16
C1_n5 x1_n5 0 3.839100e-16
C1_n6 x1_n6 0 2.405740e-16
C1_n7 x1_n7 0 5.001030e-16
C1_n8 x1_n8 0 1.097920e-16
C1_n9 x1_n9 0 4.798760e-16
C1_n10 x1_n10 0 6.970820e-16
C1_n11 x1_n11 0 3.954930e-16
C1_n12 x1_n12 0 1.634440e-16
C1_n13 x1_n13 0 3.993570e-16
C1_n14 x1_n14 0 1.628300e-16
C1_n15 x1_n15 0 1.079730e-15
C1_n16 x1_n16 0 7.896320e-16
C1_n17 x1_n17 0 3.096570e-16
C1_n18 x1_n18 0 7.961540e-16
C1_n19 x1_n19 0 6.256790e-16
C1_n20 x1_n20 0 1.264130e-16
C1_n21 x1_n21 0 1.261250e-16
C1_n22 x1_n22 0 3.204810e-16
C1_n23 x1_n23 0 1.944510e-16
C1_n24 x1_n24 0 3.287040e-16
C1_n25 x1_n25 0 5.914440e-16
C1_n26 x1_n26 0 1.705300e-16
C1_n27 x1_n27 0 4.081190e-16
C1_n28 x1_n28 0 7.948460e-16
C1_n29 x1_n29 0 6.180110e-16
C1_n30 x1_n30 0 3.613640e-16
C1_out x1_out 0 1.415750e-15
* --- RO 2 ---
X2_nand EN x2_n30 0 0 VPWR VPWR x2_n0 sky130_fd_sc_hd__nand2_1
X2_inv1 x2_n0 0 0 VPWR VPWR x2_n1 sky130_fd_sc_hd__inv_1
X2_inv2 x2_n1 0 0 VPWR VPWR x2_n2 sky130_fd_sc_hd__inv_1
X2_inv3 x2_n2 0 0 VPWR VPWR x2_n3 sky130_fd_sc_hd__inv_1
X2_inv4 x2_n3 0 0 VPWR VPWR x2_n4 sky130_fd_sc_hd__inv_1
X2_inv5 x2_n4 0 0 VPWR VPWR x2_n5 sky130_fd_sc_hd__inv_1
X2_inv6 x2_n5 0 0 VPWR VPWR x2_n6 sky130_fd_sc_hd__inv_1
X2_inv7 x2_n6 0 0 VPWR VPWR x2_n7 sky130_fd_sc_hd__inv_1
X2_inv8 x2_n7 0 0 VPWR VPWR x2_n8 sky130_fd_sc_hd__inv_1
X2_inv9 x2_n8 0 0 VPWR VPWR x2_n9 sky130_fd_sc_hd__inv_1
X2_inv10 x2_n9 0 0 VPWR VPWR x2_n10 sky130_fd_sc_hd__inv_1
X2_inv11 x2_n10 0 0 VPWR VPWR x2_n11 sky130_fd_sc_hd__inv_1
X2_inv12 x2_n11 0 0 VPWR VPWR x2_n12 sky130_fd_sc_hd__inv_1
X2_inv13 x2_n12 0 0 VPWR VPWR x2_n13 sky130_fd_sc_hd__inv_1
X2_inv14 x2_n13 0 0 VPWR VPWR x2_n14 sky130_fd_sc_hd__inv_1
X2_inv15 x2_n14 0 0 VPWR VPWR x2_n15 sky130_fd_sc_hd__inv_1
X2_inv16 x2_n15 0 0 VPWR VPWR x2_n16 sky130_fd_sc_hd__inv_1
X2_inv17 x2_n16 0 0 VPWR VPWR x2_n17 sky130_fd_sc_hd__inv_1
X2_inv18 x2_n17 0 0 VPWR VPWR x2_n18 sky130_fd_sc_hd__inv_1
X2_inv19 x2_n18 0 0 VPWR VPWR x2_n19 sky130_fd_sc_hd__inv_1
X2_inv20 x2_n19 0 0 VPWR VPWR x2_n20 sky130_fd_sc_hd__inv_1
X2_inv21 x2_n20 0 0 VPWR VPWR x2_n21 sky130_fd_sc_hd__inv_1
X2_inv22 x2_n21 0 0 VPWR VPWR x2_n22 sky130_fd_sc_hd__inv_1
X2_inv23 x2_n22 0 0 VPWR VPWR x2_n23 sky130_fd_sc_hd__inv_1
X2_inv24 x2_n23 0 0 VPWR VPWR x2_n24 sky130_fd_sc_hd__inv_1
X2_inv25 x2_n24 0 0 VPWR VPWR x2_n25 sky130_fd_sc_hd__inv_1
X2_inv26 x2_n25 0 0 VPWR VPWR x2_n26 sky130_fd_sc_hd__inv_1
X2_inv27 x2_n26 0 0 VPWR VPWR x2_n27 sky130_fd_sc_hd__inv_1
X2_inv28 x2_n27 0 0 VPWR VPWR x2_n28 sky130_fd_sc_hd__inv_1
X2_inv29 x2_n28 0 0 VPWR VPWR x2_n29 sky130_fd_sc_hd__inv_1
X2_inv30 x2_n29 0 0 VPWR VPWR x2_n30 sky130_fd_sc_hd__inv_1
X2_buf x2_n15 0 0 VPWR VPWR x2_out sky130_fd_sc_hd__buf_1
C2_n0 x2_n0 0 4.585180e-16
C2_n1 x2_n1 0 2.191740e-16
C2_n2 x2_n2 0 7.649690e-16
C2_n3 x2_n3 0 1.640160e-16
C2_n4 x2_n4 0 4.798940e-16
C2_n5 x2_n5 0 1.659360e-16
C2_n6 x2_n6 0 5.034530e-16
C2_n7 x2_n7 0 1.135650e-16
C2_n8 x2_n8 0 6.300200e-16
C2_n9 x2_n9 0 2.653580e-16
C2_n10 x2_n10 0 5.918730e-16
C2_n11 x2_n11 0 4.735550e-16
C2_n12 x2_n12 0 1.636130e-16
C2_n13 x2_n13 0 1.628300e-16
C2_n14 x2_n14 0 1.628300e-16
C2_n15 x2_n15 0 7.020680e-16
C2_n16 x2_n16 0 1.628300e-16
C2_n17 x2_n17 0 1.628300e-16
C2_n18 x2_n18 0 3.037870e-16
C2_n19 x2_n19 0 4.969600e-16
C2_n20 x2_n20 0 1.628300e-16
C2_n21 x2_n21 0 1.628300e-16
C2_n22 x2_n22 0 1.628300e-16
C2_n23 x2_n23 0 1.794380e-16
C2_n24 x2_n24 0 2.473540e-16
C2_n25 x2_n25 0 4.016430e-16
C2_n26 x2_n26 0 2.509770e-16
C2_n27 x2_n27 0 1.639940e-16
C2_n28 x2_n28 0 3.475180e-16
C2_n29 x2_n29 0 7.181890e-16
C2_n30 x2_n30 0 2.953890e-16
C2_out x2_out 0 5.780230e-16
* --- RO 3 ---
X3_nand EN x3_n30 0 0 VPWR VPWR x3_n0 sky130_fd_sc_hd__nand2_1
X3_inv1 x3_n0 0 0 VPWR VPWR x3_n1 sky130_fd_sc_hd__inv_1
X3_inv2 x3_n1 0 0 VPWR VPWR x3_n2 sky130_fd_sc_hd__inv_1
X3_inv3 x3_n2 0 0 VPWR VPWR x3_n3 sky130_fd_sc_hd__inv_1
X3_inv4 x3_n3 0 0 VPWR VPWR x3_n4 sky130_fd_sc_hd__inv_1
X3_inv5 x3_n4 0 0 VPWR VPWR x3_n5 sky130_fd_sc_hd__inv_1
X3_inv6 x3_n5 0 0 VPWR VPWR x3_n6 sky130_fd_sc_hd__inv_1
X3_inv7 x3_n6 0 0 VPWR VPWR x3_n7 sky130_fd_sc_hd__inv_1
X3_inv8 x3_n7 0 0 VPWR VPWR x3_n8 sky130_fd_sc_hd__inv_1
X3_inv9 x3_n8 0 0 VPWR VPWR x3_n9 sky130_fd_sc_hd__inv_1
X3_inv10 x3_n9 0 0 VPWR VPWR x3_n10 sky130_fd_sc_hd__inv_1
X3_inv11 x3_n10 0 0 VPWR VPWR x3_n11 sky130_fd_sc_hd__inv_1
X3_inv12 x3_n11 0 0 VPWR VPWR x3_n12 sky130_fd_sc_hd__inv_1
X3_inv13 x3_n12 0 0 VPWR VPWR x3_n13 sky130_fd_sc_hd__inv_1
X3_inv14 x3_n13 0 0 VPWR VPWR x3_n14 sky130_fd_sc_hd__inv_1
X3_inv15 x3_n14 0 0 VPWR VPWR x3_n15 sky130_fd_sc_hd__inv_1
X3_inv16 x3_n15 0 0 VPWR VPWR x3_n16 sky130_fd_sc_hd__inv_1
X3_inv17 x3_n16 0 0 VPWR VPWR x3_n17 sky130_fd_sc_hd__inv_1
X3_inv18 x3_n17 0 0 VPWR VPWR x3_n18 sky130_fd_sc_hd__inv_1
X3_inv19 x3_n18 0 0 VPWR VPWR x3_n19 sky130_fd_sc_hd__inv_1
X3_inv20 x3_n19 0 0 VPWR VPWR x3_n20 sky130_fd_sc_hd__inv_1
X3_inv21 x3_n20 0 0 VPWR VPWR x3_n21 sky130_fd_sc_hd__inv_1
X3_inv22 x3_n21 0 0 VPWR VPWR x3_n22 sky130_fd_sc_hd__inv_1
X3_inv23 x3_n22 0 0 VPWR VPWR x3_n23 sky130_fd_sc_hd__inv_1
X3_inv24 x3_n23 0 0 VPWR VPWR x3_n24 sky130_fd_sc_hd__inv_1
X3_inv25 x3_n24 0 0 VPWR VPWR x3_n25 sky130_fd_sc_hd__inv_1
X3_inv26 x3_n25 0 0 VPWR VPWR x3_n26 sky130_fd_sc_hd__inv_1
X3_inv27 x3_n26 0 0 VPWR VPWR x3_n27 sky130_fd_sc_hd__inv_1
X3_inv28 x3_n27 0 0 VPWR VPWR x3_n28 sky130_fd_sc_hd__inv_1
X3_inv29 x3_n28 0 0 VPWR VPWR x3_n29 sky130_fd_sc_hd__inv_1
X3_inv30 x3_n29 0 0 VPWR VPWR x3_n30 sky130_fd_sc_hd__inv_1
X3_buf x3_n15 0 0 VPWR VPWR x3_out sky130_fd_sc_hd__buf_1
C3_n0 x3_n0 0 2.482520e-16
C3_n1 x3_n1 0 2.893150e-16
C3_n2 x3_n2 0 7.008520e-16
C3_n3 x3_n3 0 1.866250e-16
C3_n4 x3_n4 0 2.992350e-16
C3_n5 x3_n5 0 5.294310e-16
C3_n6 x3_n6 0 1.067930e-16
C3_n7 x3_n7 0 2.089530e-16
C3_n8 x3_n8 0 6.010960e-16
C3_n9 x3_n9 0 3.094730e-16
C3_n10 x3_n10 0 5.191330e-16
C3_n11 x3_n11 0 7.353540e-16
C3_n12 x3_n12 0 1.827290e-16
C3_n13 x3_n13 0 3.352650e-16
C3_n14 x3_n14 0 1.396750e-16
C3_n15 x3_n15 0 1.254160e-15
C3_n16 x3_n16 0 1.250960e-16
C3_n17 x3_n17 0 1.505970e-16
C3_n18 x3_n18 0 2.332450e-16
C3_n19 x3_n19 0 6.175820e-16
C3_n20 x3_n20 0 8.323490e-16
C3_n21 x3_n21 0 1.738930e-16
C3_n22 x3_n22 0 5.623020e-16
C3_n23 x3_n23 0 1.067930e-16
C3_n24 x3_n24 0 4.513050e-16
C3_n25 x3_n25 0 3.918340e-16
C3_n26 x3_n26 0 2.512180e-16
C3_n27 x3_n27 0 7.971680e-16
C3_n28 x3_n28 0 2.125310e-16
C3_n29 x3_n29 0 8.766140e-16
C3_n30 x3_n30 0 1.443600e-16
C3_out x3_out 0 6.130200e-16
* --- RO 4 ---
X4_nand EN x4_n30 0 0 VPWR VPWR x4_n0 sky130_fd_sc_hd__nand2_1
X4_inv1 x4_n0 0 0 VPWR VPWR x4_n1 sky130_fd_sc_hd__inv_1
X4_inv2 x4_n1 0 0 VPWR VPWR x4_n2 sky130_fd_sc_hd__inv_1
X4_inv3 x4_n2 0 0 VPWR VPWR x4_n3 sky130_fd_sc_hd__inv_1
X4_inv4 x4_n3 0 0 VPWR VPWR x4_n4 sky130_fd_sc_hd__inv_1
X4_inv5 x4_n4 0 0 VPWR VPWR x4_n5 sky130_fd_sc_hd__inv_1
X4_inv6 x4_n5 0 0 VPWR VPWR x4_n6 sky130_fd_sc_hd__inv_1
X4_inv7 x4_n6 0 0 VPWR VPWR x4_n7 sky130_fd_sc_hd__inv_1
X4_inv8 x4_n7 0 0 VPWR VPWR x4_n8 sky130_fd_sc_hd__inv_1
X4_inv9 x4_n8 0 0 VPWR VPWR x4_n9 sky130_fd_sc_hd__inv_1
X4_inv10 x4_n9 0 0 VPWR VPWR x4_n10 sky130_fd_sc_hd__inv_1
X4_inv11 x4_n10 0 0 VPWR VPWR x4_n11 sky130_fd_sc_hd__inv_1
X4_inv12 x4_n11 0 0 VPWR VPWR x4_n12 sky130_fd_sc_hd__inv_1
X4_inv13 x4_n12 0 0 VPWR VPWR x4_n13 sky130_fd_sc_hd__inv_1
X4_inv14 x4_n13 0 0 VPWR VPWR x4_n14 sky130_fd_sc_hd__inv_1
X4_inv15 x4_n14 0 0 VPWR VPWR x4_n15 sky130_fd_sc_hd__inv_1
X4_inv16 x4_n15 0 0 VPWR VPWR x4_n16 sky130_fd_sc_hd__inv_1
X4_inv17 x4_n16 0 0 VPWR VPWR x4_n17 sky130_fd_sc_hd__inv_1
X4_inv18 x4_n17 0 0 VPWR VPWR x4_n18 sky130_fd_sc_hd__inv_1
X4_inv19 x4_n18 0 0 VPWR VPWR x4_n19 sky130_fd_sc_hd__inv_1
X4_inv20 x4_n19 0 0 VPWR VPWR x4_n20 sky130_fd_sc_hd__inv_1
X4_inv21 x4_n20 0 0 VPWR VPWR x4_n21 sky130_fd_sc_hd__inv_1
X4_inv22 x4_n21 0 0 VPWR VPWR x4_n22 sky130_fd_sc_hd__inv_1
X4_inv23 x4_n22 0 0 VPWR VPWR x4_n23 sky130_fd_sc_hd__inv_1
X4_inv24 x4_n23 0 0 VPWR VPWR x4_n24 sky130_fd_sc_hd__inv_1
X4_inv25 x4_n24 0 0 VPWR VPWR x4_n25 sky130_fd_sc_hd__inv_1
X4_inv26 x4_n25 0 0 VPWR VPWR x4_n26 sky130_fd_sc_hd__inv_1
X4_inv27 x4_n26 0 0 VPWR VPWR x4_n27 sky130_fd_sc_hd__inv_1
X4_inv28 x4_n27 0 0 VPWR VPWR x4_n28 sky130_fd_sc_hd__inv_1
X4_inv29 x4_n28 0 0 VPWR VPWR x4_n29 sky130_fd_sc_hd__inv_1
X4_inv30 x4_n29 0 0 VPWR VPWR x4_n30 sky130_fd_sc_hd__inv_1
X4_buf x4_n15 0 0 VPWR VPWR x4_out sky130_fd_sc_hd__buf_1
C4_n0 x4_n0 0 2.887750e-16
C4_n1 x4_n1 0 2.045530e-16
C4_n2 x4_n2 0 3.505570e-16
C4_n3 x4_n3 0 2.458210e-16
C4_n4 x4_n4 0 1.067930e-16
C4_n5 x4_n5 0 1.560510e-16
C4_n6 x4_n6 0 4.317670e-16
C4_n7 x4_n7 0 1.070460e-16
C4_n8 x4_n8 0 1.069360e-16
C4_n9 x4_n9 0 1.176980e-16
C4_n10 x4_n10 0 1.187610e-16
C4_n11 x4_n11 0 1.629830e-16
C4_n12 x4_n12 0 7.734330e-16
C4_n13 x4_n13 0 1.062810e-15
C4_n14 x4_n14 0 1.262580e-16
C4_n15 x4_n15 0 7.257870e-16
C4_n16 x4_n16 0 1.288580e-16
C4_n17 x4_n17 0 4.079770e-16
C4_n18 x4_n18 0 1.067930e-16
C4_n19 x4_n19 0 1.067930e-16
C4_n20 x4_n20 0 1.069210e-16
C4_n21 x4_n21 0 1.070610e-16
C4_n22 x4_n22 0 1.680600e-16
C4_n23 x4_n23 0 3.525440e-16
C4_n24 x4_n24 0 2.278160e-16
C4_n25 x4_n25 0 1.070610e-16
C4_n26 x4_n26 0 1.067930e-16
C4_n27 x4_n27 0 1.067930e-16
C4_n28 x4_n28 0 1.067930e-16
C4_n29 x4_n29 0 1.067930e-16
C4_n30 x4_n30 0 9.451340e-17
C4_out x4_out 0 4.643100e-16
* --- RO 5 ---
X5_nand EN x5_n30 0 0 VPWR VPWR x5_n0 sky130_fd_sc_hd__nand2_1
X5_inv1 x5_n0 0 0 VPWR VPWR x5_n1 sky130_fd_sc_hd__inv_1
X5_inv2 x5_n1 0 0 VPWR VPWR x5_n2 sky130_fd_sc_hd__inv_1
X5_inv3 x5_n2 0 0 VPWR VPWR x5_n3 sky130_fd_sc_hd__inv_1
X5_inv4 x5_n3 0 0 VPWR VPWR x5_n4 sky130_fd_sc_hd__inv_1
X5_inv5 x5_n4 0 0 VPWR VPWR x5_n5 sky130_fd_sc_hd__inv_1
X5_inv6 x5_n5 0 0 VPWR VPWR x5_n6 sky130_fd_sc_hd__inv_1
X5_inv7 x5_n6 0 0 VPWR VPWR x5_n7 sky130_fd_sc_hd__inv_1
X5_inv8 x5_n7 0 0 VPWR VPWR x5_n8 sky130_fd_sc_hd__inv_1
X5_inv9 x5_n8 0 0 VPWR VPWR x5_n9 sky130_fd_sc_hd__inv_1
X5_inv10 x5_n9 0 0 VPWR VPWR x5_n10 sky130_fd_sc_hd__inv_1
X5_inv11 x5_n10 0 0 VPWR VPWR x5_n11 sky130_fd_sc_hd__inv_1
X5_inv12 x5_n11 0 0 VPWR VPWR x5_n12 sky130_fd_sc_hd__inv_1
X5_inv13 x5_n12 0 0 VPWR VPWR x5_n13 sky130_fd_sc_hd__inv_1
X5_inv14 x5_n13 0 0 VPWR VPWR x5_n14 sky130_fd_sc_hd__inv_1
X5_inv15 x5_n14 0 0 VPWR VPWR x5_n15 sky130_fd_sc_hd__inv_1
X5_inv16 x5_n15 0 0 VPWR VPWR x5_n16 sky130_fd_sc_hd__inv_1
X5_inv17 x5_n16 0 0 VPWR VPWR x5_n17 sky130_fd_sc_hd__inv_1
X5_inv18 x5_n17 0 0 VPWR VPWR x5_n18 sky130_fd_sc_hd__inv_1
X5_inv19 x5_n18 0 0 VPWR VPWR x5_n19 sky130_fd_sc_hd__inv_1
X5_inv20 x5_n19 0 0 VPWR VPWR x5_n20 sky130_fd_sc_hd__inv_1
X5_inv21 x5_n20 0 0 VPWR VPWR x5_n21 sky130_fd_sc_hd__inv_1
X5_inv22 x5_n21 0 0 VPWR VPWR x5_n22 sky130_fd_sc_hd__inv_1
X5_inv23 x5_n22 0 0 VPWR VPWR x5_n23 sky130_fd_sc_hd__inv_1
X5_inv24 x5_n23 0 0 VPWR VPWR x5_n24 sky130_fd_sc_hd__inv_1
X5_inv25 x5_n24 0 0 VPWR VPWR x5_n25 sky130_fd_sc_hd__inv_1
X5_inv26 x5_n25 0 0 VPWR VPWR x5_n26 sky130_fd_sc_hd__inv_1
X5_inv27 x5_n26 0 0 VPWR VPWR x5_n27 sky130_fd_sc_hd__inv_1
X5_inv28 x5_n27 0 0 VPWR VPWR x5_n28 sky130_fd_sc_hd__inv_1
X5_inv29 x5_n28 0 0 VPWR VPWR x5_n29 sky130_fd_sc_hd__inv_1
X5_inv30 x5_n29 0 0 VPWR VPWR x5_n30 sky130_fd_sc_hd__inv_1
X5_buf x5_n15 0 0 VPWR VPWR x5_out sky130_fd_sc_hd__buf_1
C5_n0 x5_n0 0 4.903900e-16
C5_n1 x5_n1 0 3.628030e-16
C5_n2 x5_n2 0 4.880500e-16
C5_n3 x5_n3 0 1.819180e-16
C5_n4 x5_n4 0 4.617750e-16
C5_n5 x5_n5 0 6.084520e-16
C5_n6 x5_n6 0 2.530080e-16
C5_n7 x5_n7 0 5.705550e-16
C5_n8 x5_n8 0 3.021310e-16
C5_n9 x5_n9 0 4.985040e-16
C5_n10 x5_n10 0 2.480200e-16
C5_n11 x5_n11 0 3.298440e-16
C5_n12 x5_n12 0 1.962520e-16
C5_n13 x5_n13 0 1.559410e-16
C5_n14 x5_n14 0 7.100780e-16
C5_n15 x5_n15 0 9.655750e-16
C5_n16 x5_n16 0 4.320380e-16
C5_n17 x5_n17 0 1.647750e-16
C5_n18 x5_n18 0 4.795830e-16
C5_n19 x5_n19 0 9.046710e-16
C5_n20 x5_n20 0 2.229520e-16
C5_n21 x5_n21 0 1.972450e-16
C5_n22 x5_n22 0 8.478770e-16
C5_n23 x5_n23 0 6.694260e-16
C5_n24 x5_n24 0 2.469290e-16
C5_n25 x5_n25 0 3.913910e-16
C5_n26 x5_n26 0 2.464440e-16
C5_n27 x5_n27 0 5.475940e-16
C5_n28 x5_n28 0 1.250640e-16
C5_n29 x5_n29 0 1.336520e-16
C5_n30 x5_n30 0 8.747940e-16
C5_out x5_out 0 3.793830e-16
* --- RO 6 ---
X6_nand EN x6_n30 0 0 VPWR VPWR x6_n0 sky130_fd_sc_hd__nand2_1
X6_inv1 x6_n0 0 0 VPWR VPWR x6_n1 sky130_fd_sc_hd__inv_1
X6_inv2 x6_n1 0 0 VPWR VPWR x6_n2 sky130_fd_sc_hd__inv_1
X6_inv3 x6_n2 0 0 VPWR VPWR x6_n3 sky130_fd_sc_hd__inv_1
X6_inv4 x6_n3 0 0 VPWR VPWR x6_n4 sky130_fd_sc_hd__inv_1
X6_inv5 x6_n4 0 0 VPWR VPWR x6_n5 sky130_fd_sc_hd__inv_1
X6_inv6 x6_n5 0 0 VPWR VPWR x6_n6 sky130_fd_sc_hd__inv_1
X6_inv7 x6_n6 0 0 VPWR VPWR x6_n7 sky130_fd_sc_hd__inv_1
X6_inv8 x6_n7 0 0 VPWR VPWR x6_n8 sky130_fd_sc_hd__inv_1
X6_inv9 x6_n8 0 0 VPWR VPWR x6_n9 sky130_fd_sc_hd__inv_1
X6_inv10 x6_n9 0 0 VPWR VPWR x6_n10 sky130_fd_sc_hd__inv_1
X6_inv11 x6_n10 0 0 VPWR VPWR x6_n11 sky130_fd_sc_hd__inv_1
X6_inv12 x6_n11 0 0 VPWR VPWR x6_n12 sky130_fd_sc_hd__inv_1
X6_inv13 x6_n12 0 0 VPWR VPWR x6_n13 sky130_fd_sc_hd__inv_1
X6_inv14 x6_n13 0 0 VPWR VPWR x6_n14 sky130_fd_sc_hd__inv_1
X6_inv15 x6_n14 0 0 VPWR VPWR x6_n15 sky130_fd_sc_hd__inv_1
X6_inv16 x6_n15 0 0 VPWR VPWR x6_n16 sky130_fd_sc_hd__inv_1
X6_inv17 x6_n16 0 0 VPWR VPWR x6_n17 sky130_fd_sc_hd__inv_1
X6_inv18 x6_n17 0 0 VPWR VPWR x6_n18 sky130_fd_sc_hd__inv_1
X6_inv19 x6_n18 0 0 VPWR VPWR x6_n19 sky130_fd_sc_hd__inv_1
X6_inv20 x6_n19 0 0 VPWR VPWR x6_n20 sky130_fd_sc_hd__inv_1
X6_inv21 x6_n20 0 0 VPWR VPWR x6_n21 sky130_fd_sc_hd__inv_1
X6_inv22 x6_n21 0 0 VPWR VPWR x6_n22 sky130_fd_sc_hd__inv_1
X6_inv23 x6_n22 0 0 VPWR VPWR x6_n23 sky130_fd_sc_hd__inv_1
X6_inv24 x6_n23 0 0 VPWR VPWR x6_n24 sky130_fd_sc_hd__inv_1
X6_inv25 x6_n24 0 0 VPWR VPWR x6_n25 sky130_fd_sc_hd__inv_1
X6_inv26 x6_n25 0 0 VPWR VPWR x6_n26 sky130_fd_sc_hd__inv_1
X6_inv27 x6_n26 0 0 VPWR VPWR x6_n27 sky130_fd_sc_hd__inv_1
X6_inv28 x6_n27 0 0 VPWR VPWR x6_n28 sky130_fd_sc_hd__inv_1
X6_inv29 x6_n28 0 0 VPWR VPWR x6_n29 sky130_fd_sc_hd__inv_1
X6_inv30 x6_n29 0 0 VPWR VPWR x6_n30 sky130_fd_sc_hd__inv_1
X6_buf x6_n15 0 0 VPWR VPWR x6_out sky130_fd_sc_hd__buf_1
C6_n0 x6_n0 0 2.483730e-16
C6_n1 x6_n1 0 4.209840e-16
C6_n2 x6_n2 0 1.067930e-16
C6_n3 x6_n3 0 2.580050e-16
C6_n4 x6_n4 0 4.012150e-16
C6_n5 x6_n5 0 1.067930e-16
C6_n6 x6_n6 0 1.067930e-16
C6_n7 x6_n7 0 3.669300e-16
C6_n8 x6_n8 0 4.374440e-16
C6_n9 x6_n9 0 1.067930e-16
C6_n10 x6_n10 0 1.067930e-16
C6_n11 x6_n11 0 1.067930e-16
C6_n12 x6_n12 0 7.543580e-16
C6_n13 x6_n13 0 5.742030e-16
C6_n14 x6_n14 0 3.327110e-16
C6_n15 x6_n15 0 8.408230e-16
C6_n16 x6_n16 0 1.067930e-16
C6_n17 x6_n17 0 1.067930e-16
C6_n18 x6_n18 0 3.717420e-16
C6_n19 x6_n19 0 5.419870e-16
C6_n20 x6_n20 0 6.246310e-16
C6_n21 x6_n21 0 1.067930e-16
C6_n22 x6_n22 0 1.556730e-16
C6_n23 x6_n23 0 1.067960e-16
C6_n24 x6_n24 0 5.494450e-16
C6_n25 x6_n25 0 5.636760e-16
C6_n26 x6_n26 0 3.979010e-16
C6_n27 x6_n27 0 6.805100e-16
C6_n28 x6_n28 0 1.070650e-16
C6_n29 x6_n29 0 3.458090e-16
C6_n30 x6_n30 0 1.370960e-16
C6_out x6_out 0 4.789980e-16
* --- RO 7 ---
X7_nand EN x7_n30 0 0 VPWR VPWR x7_n0 sky130_fd_sc_hd__nand2_1
X7_inv1 x7_n0 0 0 VPWR VPWR x7_n1 sky130_fd_sc_hd__inv_1
X7_inv2 x7_n1 0 0 VPWR VPWR x7_n2 sky130_fd_sc_hd__inv_1
X7_inv3 x7_n2 0 0 VPWR VPWR x7_n3 sky130_fd_sc_hd__inv_1
X7_inv4 x7_n3 0 0 VPWR VPWR x7_n4 sky130_fd_sc_hd__inv_1
X7_inv5 x7_n4 0 0 VPWR VPWR x7_n5 sky130_fd_sc_hd__inv_1
X7_inv6 x7_n5 0 0 VPWR VPWR x7_n6 sky130_fd_sc_hd__inv_1
X7_inv7 x7_n6 0 0 VPWR VPWR x7_n7 sky130_fd_sc_hd__inv_1
X7_inv8 x7_n7 0 0 VPWR VPWR x7_n8 sky130_fd_sc_hd__inv_1
X7_inv9 x7_n8 0 0 VPWR VPWR x7_n9 sky130_fd_sc_hd__inv_1
X7_inv10 x7_n9 0 0 VPWR VPWR x7_n10 sky130_fd_sc_hd__inv_1
X7_inv11 x7_n10 0 0 VPWR VPWR x7_n11 sky130_fd_sc_hd__inv_1
X7_inv12 x7_n11 0 0 VPWR VPWR x7_n12 sky130_fd_sc_hd__inv_1
X7_inv13 x7_n12 0 0 VPWR VPWR x7_n13 sky130_fd_sc_hd__inv_1
X7_inv14 x7_n13 0 0 VPWR VPWR x7_n14 sky130_fd_sc_hd__inv_1
X7_inv15 x7_n14 0 0 VPWR VPWR x7_n15 sky130_fd_sc_hd__inv_1
X7_inv16 x7_n15 0 0 VPWR VPWR x7_n16 sky130_fd_sc_hd__inv_1
X7_inv17 x7_n16 0 0 VPWR VPWR x7_n17 sky130_fd_sc_hd__inv_1
X7_inv18 x7_n17 0 0 VPWR VPWR x7_n18 sky130_fd_sc_hd__inv_1
X7_inv19 x7_n18 0 0 VPWR VPWR x7_n19 sky130_fd_sc_hd__inv_1
X7_inv20 x7_n19 0 0 VPWR VPWR x7_n20 sky130_fd_sc_hd__inv_1
X7_inv21 x7_n20 0 0 VPWR VPWR x7_n21 sky130_fd_sc_hd__inv_1
X7_inv22 x7_n21 0 0 VPWR VPWR x7_n22 sky130_fd_sc_hd__inv_1
X7_inv23 x7_n22 0 0 VPWR VPWR x7_n23 sky130_fd_sc_hd__inv_1
X7_inv24 x7_n23 0 0 VPWR VPWR x7_n24 sky130_fd_sc_hd__inv_1
X7_inv25 x7_n24 0 0 VPWR VPWR x7_n25 sky130_fd_sc_hd__inv_1
X7_inv26 x7_n25 0 0 VPWR VPWR x7_n26 sky130_fd_sc_hd__inv_1
X7_inv27 x7_n26 0 0 VPWR VPWR x7_n27 sky130_fd_sc_hd__inv_1
X7_inv28 x7_n27 0 0 VPWR VPWR x7_n28 sky130_fd_sc_hd__inv_1
X7_inv29 x7_n28 0 0 VPWR VPWR x7_n29 sky130_fd_sc_hd__inv_1
X7_inv30 x7_n29 0 0 VPWR VPWR x7_n30 sky130_fd_sc_hd__inv_1
X7_buf x7_n15 0 0 VPWR VPWR x7_out sky130_fd_sc_hd__buf_1
C7_n0 x7_n0 0 7.547940e-16
C7_n1 x7_n1 0 1.747980e-16
C7_n2 x7_n2 0 1.814120e-16
C7_n3 x7_n3 0 2.203370e-16
C7_n4 x7_n4 0 3.159980e-16
C7_n5 x7_n5 0 6.102720e-16
C7_n6 x7_n6 0 1.887540e-16
C7_n7 x7_n7 0 5.852270e-16
C7_n8 x7_n8 0 4.759600e-16
C7_n9 x7_n9 0 6.518990e-16
C7_n10 x7_n10 0 2.992350e-16
C7_n11 x7_n11 0 5.232070e-16
C7_n12 x7_n12 0 5.822460e-16
C7_n13 x7_n13 0 2.281230e-16
C7_n14 x7_n14 0 1.564940e-16
C7_n15 x7_n15 0 1.261320e-15
C7_n16 x7_n16 0 1.067930e-16
C7_n17 x7_n17 0 1.067930e-16
C7_n18 x7_n18 0 1.067930e-16
C7_n19 x7_n19 0 1.067930e-16
C7_n20 x7_n20 0 1.067930e-16
C7_n21 x7_n21 0 3.361590e-16
C7_n22 x7_n22 0 1.564940e-16
C7_n23 x7_n23 0 4.109010e-16
C7_n24 x7_n24 0 3.652070e-16
C7_n25 x7_n25 0 8.153100e-16
C7_n26 x7_n26 0 5.675800e-16
C7_n27 x7_n27 0 2.034810e-16
C7_n28 x7_n28 0 5.145690e-16
C7_n29 x7_n29 0 1.600330e-16
C7_n30 x7_n30 0 1.151360e-15
C7_out x7_out 0 5.828480e-16
* --- RO 8 ---
X8_nand EN x8_n30 0 0 VPWR VPWR x8_n0 sky130_fd_sc_hd__nand2_1
X8_inv1 x8_n0 0 0 VPWR VPWR x8_n1 sky130_fd_sc_hd__inv_1
X8_inv2 x8_n1 0 0 VPWR VPWR x8_n2 sky130_fd_sc_hd__inv_1
X8_inv3 x8_n2 0 0 VPWR VPWR x8_n3 sky130_fd_sc_hd__inv_1
X8_inv4 x8_n3 0 0 VPWR VPWR x8_n4 sky130_fd_sc_hd__inv_1
X8_inv5 x8_n4 0 0 VPWR VPWR x8_n5 sky130_fd_sc_hd__inv_1
X8_inv6 x8_n5 0 0 VPWR VPWR x8_n6 sky130_fd_sc_hd__inv_1
X8_inv7 x8_n6 0 0 VPWR VPWR x8_n7 sky130_fd_sc_hd__inv_1
X8_inv8 x8_n7 0 0 VPWR VPWR x8_n8 sky130_fd_sc_hd__inv_1
X8_inv9 x8_n8 0 0 VPWR VPWR x8_n9 sky130_fd_sc_hd__inv_1
X8_inv10 x8_n9 0 0 VPWR VPWR x8_n10 sky130_fd_sc_hd__inv_1
X8_inv11 x8_n10 0 0 VPWR VPWR x8_n11 sky130_fd_sc_hd__inv_1
X8_inv12 x8_n11 0 0 VPWR VPWR x8_n12 sky130_fd_sc_hd__inv_1
X8_inv13 x8_n12 0 0 VPWR VPWR x8_n13 sky130_fd_sc_hd__inv_1
X8_inv14 x8_n13 0 0 VPWR VPWR x8_n14 sky130_fd_sc_hd__inv_1
X8_inv15 x8_n14 0 0 VPWR VPWR x8_n15 sky130_fd_sc_hd__inv_1
X8_inv16 x8_n15 0 0 VPWR VPWR x8_n16 sky130_fd_sc_hd__inv_1
X8_inv17 x8_n16 0 0 VPWR VPWR x8_n17 sky130_fd_sc_hd__inv_1
X8_inv18 x8_n17 0 0 VPWR VPWR x8_n18 sky130_fd_sc_hd__inv_1
X8_inv19 x8_n18 0 0 VPWR VPWR x8_n19 sky130_fd_sc_hd__inv_1
X8_inv20 x8_n19 0 0 VPWR VPWR x8_n20 sky130_fd_sc_hd__inv_1
X8_inv21 x8_n20 0 0 VPWR VPWR x8_n21 sky130_fd_sc_hd__inv_1
X8_inv22 x8_n21 0 0 VPWR VPWR x8_n22 sky130_fd_sc_hd__inv_1
X8_inv23 x8_n22 0 0 VPWR VPWR x8_n23 sky130_fd_sc_hd__inv_1
X8_inv24 x8_n23 0 0 VPWR VPWR x8_n24 sky130_fd_sc_hd__inv_1
X8_inv25 x8_n24 0 0 VPWR VPWR x8_n25 sky130_fd_sc_hd__inv_1
X8_inv26 x8_n25 0 0 VPWR VPWR x8_n26 sky130_fd_sc_hd__inv_1
X8_inv27 x8_n26 0 0 VPWR VPWR x8_n27 sky130_fd_sc_hd__inv_1
X8_inv28 x8_n27 0 0 VPWR VPWR x8_n28 sky130_fd_sc_hd__inv_1
X8_inv29 x8_n28 0 0 VPWR VPWR x8_n29 sky130_fd_sc_hd__inv_1
X8_inv30 x8_n29 0 0 VPWR VPWR x8_n30 sky130_fd_sc_hd__inv_1
X8_buf x8_n15 0 0 VPWR VPWR x8_out sky130_fd_sc_hd__buf_1
C8_n0 x8_n0 0 3.814940e-16
C8_n1 x8_n1 0 1.629830e-16
C8_n2 x8_n2 0 7.131800e-16
C8_n3 x8_n3 0 1.067930e-16
C8_n4 x8_n4 0 5.080400e-16
C8_n5 x8_n5 0 2.396430e-16
C8_n6 x8_n6 0 3.914690e-16
C8_n7 x8_n7 0 1.067930e-16
C8_n8 x8_n8 0 1.067930e-16
C8_n9 x8_n9 0 1.067930e-16
C8_n10 x8_n10 0 1.067930e-16
C8_n11 x8_n11 0 4.423010e-16
C8_n12 x8_n12 0 2.045530e-16
C8_n13 x8_n13 0 6.058210e-16
C8_n14 x8_n14 0 9.739810e-16
C8_n15 x8_n15 0 5.819950e-16
C8_n16 x8_n16 0 1.747980e-16
C8_n17 x8_n17 0 1.747980e-16
C8_n18 x8_n18 0 1.747980e-16
C8_n19 x8_n19 0 1.747980e-16
C8_n20 x8_n20 0 1.870390e-16
C8_n21 x8_n21 0 1.755810e-16
C8_n22 x8_n22 0 1.747980e-16
C8_n23 x8_n23 0 8.498830e-16
C8_n24 x8_n24 0 5.764100e-16
C8_n25 x8_n25 0 1.801760e-16
C8_n26 x8_n26 0 1.628300e-16
C8_n27 x8_n27 0 1.628300e-16
C8_n28 x8_n28 0 1.628300e-16
C8_n29 x8_n29 0 1.628300e-16
C8_n30 x8_n30 0 8.598130e-16
C8_out x8_out 0 2.374660e-15
* --- RO 9 ---
X9_nand EN x9_n30 0 0 VPWR VPWR x9_n0 sky130_fd_sc_hd__nand2_1
X9_inv1 x9_n0 0 0 VPWR VPWR x9_n1 sky130_fd_sc_hd__inv_1
X9_inv2 x9_n1 0 0 VPWR VPWR x9_n2 sky130_fd_sc_hd__inv_1
X9_inv3 x9_n2 0 0 VPWR VPWR x9_n3 sky130_fd_sc_hd__inv_1
X9_inv4 x9_n3 0 0 VPWR VPWR x9_n4 sky130_fd_sc_hd__inv_1
X9_inv5 x9_n4 0 0 VPWR VPWR x9_n5 sky130_fd_sc_hd__inv_1
X9_inv6 x9_n5 0 0 VPWR VPWR x9_n6 sky130_fd_sc_hd__inv_1
X9_inv7 x9_n6 0 0 VPWR VPWR x9_n7 sky130_fd_sc_hd__inv_1
X9_inv8 x9_n7 0 0 VPWR VPWR x9_n8 sky130_fd_sc_hd__inv_1
X9_inv9 x9_n8 0 0 VPWR VPWR x9_n9 sky130_fd_sc_hd__inv_1
X9_inv10 x9_n9 0 0 VPWR VPWR x9_n10 sky130_fd_sc_hd__inv_1
X9_inv11 x9_n10 0 0 VPWR VPWR x9_n11 sky130_fd_sc_hd__inv_1
X9_inv12 x9_n11 0 0 VPWR VPWR x9_n12 sky130_fd_sc_hd__inv_1
X9_inv13 x9_n12 0 0 VPWR VPWR x9_n13 sky130_fd_sc_hd__inv_1
X9_inv14 x9_n13 0 0 VPWR VPWR x9_n14 sky130_fd_sc_hd__inv_1
X9_inv15 x9_n14 0 0 VPWR VPWR x9_n15 sky130_fd_sc_hd__inv_1
X9_inv16 x9_n15 0 0 VPWR VPWR x9_n16 sky130_fd_sc_hd__inv_1
X9_inv17 x9_n16 0 0 VPWR VPWR x9_n17 sky130_fd_sc_hd__inv_1
X9_inv18 x9_n17 0 0 VPWR VPWR x9_n18 sky130_fd_sc_hd__inv_1
X9_inv19 x9_n18 0 0 VPWR VPWR x9_n19 sky130_fd_sc_hd__inv_1
X9_inv20 x9_n19 0 0 VPWR VPWR x9_n20 sky130_fd_sc_hd__inv_1
X9_inv21 x9_n20 0 0 VPWR VPWR x9_n21 sky130_fd_sc_hd__inv_1
X9_inv22 x9_n21 0 0 VPWR VPWR x9_n22 sky130_fd_sc_hd__inv_1
X9_inv23 x9_n22 0 0 VPWR VPWR x9_n23 sky130_fd_sc_hd__inv_1
X9_inv24 x9_n23 0 0 VPWR VPWR x9_n24 sky130_fd_sc_hd__inv_1
X9_inv25 x9_n24 0 0 VPWR VPWR x9_n25 sky130_fd_sc_hd__inv_1
X9_inv26 x9_n25 0 0 VPWR VPWR x9_n26 sky130_fd_sc_hd__inv_1
X9_inv27 x9_n26 0 0 VPWR VPWR x9_n27 sky130_fd_sc_hd__inv_1
X9_inv28 x9_n27 0 0 VPWR VPWR x9_n28 sky130_fd_sc_hd__inv_1
X9_inv29 x9_n28 0 0 VPWR VPWR x9_n29 sky130_fd_sc_hd__inv_1
X9_inv30 x9_n29 0 0 VPWR VPWR x9_n30 sky130_fd_sc_hd__inv_1
X9_buf x9_n15 0 0 VPWR VPWR x9_out sky130_fd_sc_hd__buf_1
C9_n0 x9_n0 0 3.128370e-16
C9_n1 x9_n1 0 6.003140e-16
C9_n2 x9_n2 0 6.337980e-16
C9_n3 x9_n3 0 2.918860e-16
C9_n4 x9_n4 0 4.833660e-16
C9_n5 x9_n5 0 7.492050e-16
C9_n6 x9_n6 0 9.225000e-16
C9_n7 x9_n7 0 1.860150e-16
C9_n8 x9_n8 0 5.424200e-16
C9_n9 x9_n9 0 8.620790e-16
C9_n10 x9_n10 0 6.256130e-16
C9_n11 x9_n11 0 1.087780e-16
C9_n12 x9_n12 0 1.725020e-16
C9_n13 x9_n13 0 6.430800e-16
C9_n14 x9_n14 0 2.229520e-16
C9_n15 x9_n15 0 1.696770e-15
C9_n16 x9_n16 0 1.619220e-16
C9_n17 x9_n17 0 3.156840e-16
C9_n18 x9_n18 0 3.383110e-16
C9_n19 x9_n19 0 2.910010e-16
C9_n20 x9_n20 0 4.159210e-16
C9_n21 x9_n21 0 5.988220e-16
C9_n22 x9_n22 0 1.750550e-16
C9_n23 x9_n23 0 5.447130e-16
C9_n24 x9_n24 0 7.437810e-16
C9_n25 x9_n25 0 4.437860e-16
C9_n26 x9_n26 0 2.125310e-16
C9_n27 x9_n27 0 2.125310e-16
C9_n28 x9_n28 0 2.125310e-16
C9_n29 x9_n29 0 4.253830e-16
C9_n30 x9_n30 0 3.421200e-16
C9_out x9_out 0 2.735860e-16
* --- RO 10 ---
X10_nand EN x10_n30 0 0 VPWR VPWR x10_n0 sky130_fd_sc_hd__nand2_1
X10_inv1 x10_n0 0 0 VPWR VPWR x10_n1 sky130_fd_sc_hd__inv_1
X10_inv2 x10_n1 0 0 VPWR VPWR x10_n2 sky130_fd_sc_hd__inv_1
X10_inv3 x10_n2 0 0 VPWR VPWR x10_n3 sky130_fd_sc_hd__inv_1
X10_inv4 x10_n3 0 0 VPWR VPWR x10_n4 sky130_fd_sc_hd__inv_1
X10_inv5 x10_n4 0 0 VPWR VPWR x10_n5 sky130_fd_sc_hd__inv_1
X10_inv6 x10_n5 0 0 VPWR VPWR x10_n6 sky130_fd_sc_hd__inv_1
X10_inv7 x10_n6 0 0 VPWR VPWR x10_n7 sky130_fd_sc_hd__inv_1
X10_inv8 x10_n7 0 0 VPWR VPWR x10_n8 sky130_fd_sc_hd__inv_1
X10_inv9 x10_n8 0 0 VPWR VPWR x10_n9 sky130_fd_sc_hd__inv_1
X10_inv10 x10_n9 0 0 VPWR VPWR x10_n10 sky130_fd_sc_hd__inv_1
X10_inv11 x10_n10 0 0 VPWR VPWR x10_n11 sky130_fd_sc_hd__inv_1
X10_inv12 x10_n11 0 0 VPWR VPWR x10_n12 sky130_fd_sc_hd__inv_1
X10_inv13 x10_n12 0 0 VPWR VPWR x10_n13 sky130_fd_sc_hd__inv_1
X10_inv14 x10_n13 0 0 VPWR VPWR x10_n14 sky130_fd_sc_hd__inv_1
X10_inv15 x10_n14 0 0 VPWR VPWR x10_n15 sky130_fd_sc_hd__inv_1
X10_inv16 x10_n15 0 0 VPWR VPWR x10_n16 sky130_fd_sc_hd__inv_1
X10_inv17 x10_n16 0 0 VPWR VPWR x10_n17 sky130_fd_sc_hd__inv_1
X10_inv18 x10_n17 0 0 VPWR VPWR x10_n18 sky130_fd_sc_hd__inv_1
X10_inv19 x10_n18 0 0 VPWR VPWR x10_n19 sky130_fd_sc_hd__inv_1
X10_inv20 x10_n19 0 0 VPWR VPWR x10_n20 sky130_fd_sc_hd__inv_1
X10_inv21 x10_n20 0 0 VPWR VPWR x10_n21 sky130_fd_sc_hd__inv_1
X10_inv22 x10_n21 0 0 VPWR VPWR x10_n22 sky130_fd_sc_hd__inv_1
X10_inv23 x10_n22 0 0 VPWR VPWR x10_n23 sky130_fd_sc_hd__inv_1
X10_inv24 x10_n23 0 0 VPWR VPWR x10_n24 sky130_fd_sc_hd__inv_1
X10_inv25 x10_n24 0 0 VPWR VPWR x10_n25 sky130_fd_sc_hd__inv_1
X10_inv26 x10_n25 0 0 VPWR VPWR x10_n26 sky130_fd_sc_hd__inv_1
X10_inv27 x10_n26 0 0 VPWR VPWR x10_n27 sky130_fd_sc_hd__inv_1
X10_inv28 x10_n27 0 0 VPWR VPWR x10_n28 sky130_fd_sc_hd__inv_1
X10_inv29 x10_n28 0 0 VPWR VPWR x10_n29 sky130_fd_sc_hd__inv_1
X10_inv30 x10_n29 0 0 VPWR VPWR x10_n30 sky130_fd_sc_hd__inv_1
X10_buf x10_n15 0 0 VPWR VPWR x10_out sky130_fd_sc_hd__buf_1
C10_n0 x10_n0 0 2.773780e-16
C10_n1 x10_n1 0 5.921830e-16
C10_n2 x10_n2 0 8.159720e-16
C10_n3 x10_n3 0 2.309480e-16
C10_n4 x10_n4 0 4.845660e-16
C10_n5 x10_n5 0 8.354550e-16
C10_n6 x10_n6 0 7.879530e-16
C10_n7 x10_n7 0 2.751320e-16
C10_n8 x10_n8 0 5.467050e-16
C10_n9 x10_n9 0 8.960480e-16
C10_n10 x10_n10 0 1.184480e-15
C10_n11 x10_n11 0 2.922660e-16
C10_n12 x10_n12 0 5.488110e-16
C10_n13 x10_n13 0 8.363840e-16
C10_n14 x10_n14 0 6.362480e-16
C10_n15 x10_n15 0 4.545800e-15
C10_n16 x10_n16 0 2.045720e-16
C10_n17 x10_n17 0 1.067930e-16
C10_n18 x10_n18 0 1.608010e-16
C10_n19 x10_n19 0 3.360660e-16
C10_n20 x10_n20 0 4.811280e-16
C10_n21 x10_n21 0 1.887540e-16
C10_n22 x10_n22 0 6.906720e-16
C10_n23 x10_n23 0 1.168900e-16
C10_n24 x10_n24 0 1.570420e-16
C10_n25 x10_n25 0 5.619740e-16
C10_n26 x10_n26 0 1.067930e-16
C10_n27 x10_n27 0 1.067930e-16
C10_n28 x10_n28 0 1.067930e-16
C10_n29 x10_n29 0 2.534370e-16
C10_n30 x10_n30 0 3.961420e-16
C10_out x10_out 0 5.008080e-16
* --- RO 11 ---
X11_nand EN x11_n30 0 0 VPWR VPWR x11_n0 sky130_fd_sc_hd__nand2_1
X11_inv1 x11_n0 0 0 VPWR VPWR x11_n1 sky130_fd_sc_hd__inv_1
X11_inv2 x11_n1 0 0 VPWR VPWR x11_n2 sky130_fd_sc_hd__inv_1
X11_inv3 x11_n2 0 0 VPWR VPWR x11_n3 sky130_fd_sc_hd__inv_1
X11_inv4 x11_n3 0 0 VPWR VPWR x11_n4 sky130_fd_sc_hd__inv_1
X11_inv5 x11_n4 0 0 VPWR VPWR x11_n5 sky130_fd_sc_hd__inv_1
X11_inv6 x11_n5 0 0 VPWR VPWR x11_n6 sky130_fd_sc_hd__inv_1
X11_inv7 x11_n6 0 0 VPWR VPWR x11_n7 sky130_fd_sc_hd__inv_1
X11_inv8 x11_n7 0 0 VPWR VPWR x11_n8 sky130_fd_sc_hd__inv_1
X11_inv9 x11_n8 0 0 VPWR VPWR x11_n9 sky130_fd_sc_hd__inv_1
X11_inv10 x11_n9 0 0 VPWR VPWR x11_n10 sky130_fd_sc_hd__inv_1
X11_inv11 x11_n10 0 0 VPWR VPWR x11_n11 sky130_fd_sc_hd__inv_1
X11_inv12 x11_n11 0 0 VPWR VPWR x11_n12 sky130_fd_sc_hd__inv_1
X11_inv13 x11_n12 0 0 VPWR VPWR x11_n13 sky130_fd_sc_hd__inv_1
X11_inv14 x11_n13 0 0 VPWR VPWR x11_n14 sky130_fd_sc_hd__inv_1
X11_inv15 x11_n14 0 0 VPWR VPWR x11_n15 sky130_fd_sc_hd__inv_1
X11_inv16 x11_n15 0 0 VPWR VPWR x11_n16 sky130_fd_sc_hd__inv_1
X11_inv17 x11_n16 0 0 VPWR VPWR x11_n17 sky130_fd_sc_hd__inv_1
X11_inv18 x11_n17 0 0 VPWR VPWR x11_n18 sky130_fd_sc_hd__inv_1
X11_inv19 x11_n18 0 0 VPWR VPWR x11_n19 sky130_fd_sc_hd__inv_1
X11_inv20 x11_n19 0 0 VPWR VPWR x11_n20 sky130_fd_sc_hd__inv_1
X11_inv21 x11_n20 0 0 VPWR VPWR x11_n21 sky130_fd_sc_hd__inv_1
X11_inv22 x11_n21 0 0 VPWR VPWR x11_n22 sky130_fd_sc_hd__inv_1
X11_inv23 x11_n22 0 0 VPWR VPWR x11_n23 sky130_fd_sc_hd__inv_1
X11_inv24 x11_n23 0 0 VPWR VPWR x11_n24 sky130_fd_sc_hd__inv_1
X11_inv25 x11_n24 0 0 VPWR VPWR x11_n25 sky130_fd_sc_hd__inv_1
X11_inv26 x11_n25 0 0 VPWR VPWR x11_n26 sky130_fd_sc_hd__inv_1
X11_inv27 x11_n26 0 0 VPWR VPWR x11_n27 sky130_fd_sc_hd__inv_1
X11_inv28 x11_n27 0 0 VPWR VPWR x11_n28 sky130_fd_sc_hd__inv_1
X11_inv29 x11_n28 0 0 VPWR VPWR x11_n29 sky130_fd_sc_hd__inv_1
X11_inv30 x11_n29 0 0 VPWR VPWR x11_n30 sky130_fd_sc_hd__inv_1
X11_buf x11_n15 0 0 VPWR VPWR x11_out sky130_fd_sc_hd__buf_1
C11_n0 x11_n0 0 1.019160e-15
C11_n1 x11_n1 0 2.992350e-16
C11_n2 x11_n2 0 6.366540e-16
C11_n3 x11_n3 0 2.794800e-16
C11_n4 x11_n4 0 4.810320e-16
C11_n5 x11_n5 0 3.935240e-16
C11_n6 x11_n6 0 1.067930e-16
C11_n7 x11_n7 0 1.067930e-16
C11_n8 x11_n8 0 3.889400e-16
C11_n9 x11_n9 0 2.780860e-16
C11_n10 x11_n10 0 3.836630e-16
C11_n11 x11_n11 0 1.547660e-16
C11_n12 x11_n12 0 3.167400e-16
C11_n13 x11_n13 0 1.570420e-16
C11_n14 x11_n14 0 5.611780e-16
C11_n15 x11_n15 0 6.030840e-16
C11_n16 x11_n16 0 4.836630e-16
C11_n17 x11_n17 0 2.047890e-16
C11_n18 x11_n18 0 4.560120e-16
C11_n19 x11_n19 0 1.067930e-16
C11_n20 x11_n20 0 3.535360e-16
C11_n21 x11_n21 0 1.385490e-16
C11_n22 x11_n22 0 1.760060e-16
C11_n23 x11_n23 0 5.360360e-16
C11_n24 x11_n24 0 1.093170e-16
C11_n25 x11_n25 0 4.194260e-16
C11_n26 x11_n26 0 1.716370e-16
C11_n27 x11_n27 0 4.847500e-16
C11_n28 x11_n28 0 1.073340e-16
C11_n29 x11_n29 0 1.092810e-16
C11_n30 x11_n30 0 1.078210e-16
C11_out x11_out 0 6.514860e-16
* --- RO 12 ---
X12_nand EN x12_n30 0 0 VPWR VPWR x12_n0 sky130_fd_sc_hd__nand2_1
X12_inv1 x12_n0 0 0 VPWR VPWR x12_n1 sky130_fd_sc_hd__inv_1
X12_inv2 x12_n1 0 0 VPWR VPWR x12_n2 sky130_fd_sc_hd__inv_1
X12_inv3 x12_n2 0 0 VPWR VPWR x12_n3 sky130_fd_sc_hd__inv_1
X12_inv4 x12_n3 0 0 VPWR VPWR x12_n4 sky130_fd_sc_hd__inv_1
X12_inv5 x12_n4 0 0 VPWR VPWR x12_n5 sky130_fd_sc_hd__inv_1
X12_inv6 x12_n5 0 0 VPWR VPWR x12_n6 sky130_fd_sc_hd__inv_1
X12_inv7 x12_n6 0 0 VPWR VPWR x12_n7 sky130_fd_sc_hd__inv_1
X12_inv8 x12_n7 0 0 VPWR VPWR x12_n8 sky130_fd_sc_hd__inv_1
X12_inv9 x12_n8 0 0 VPWR VPWR x12_n9 sky130_fd_sc_hd__inv_1
X12_inv10 x12_n9 0 0 VPWR VPWR x12_n10 sky130_fd_sc_hd__inv_1
X12_inv11 x12_n10 0 0 VPWR VPWR x12_n11 sky130_fd_sc_hd__inv_1
X12_inv12 x12_n11 0 0 VPWR VPWR x12_n12 sky130_fd_sc_hd__inv_1
X12_inv13 x12_n12 0 0 VPWR VPWR x12_n13 sky130_fd_sc_hd__inv_1
X12_inv14 x12_n13 0 0 VPWR VPWR x12_n14 sky130_fd_sc_hd__inv_1
X12_inv15 x12_n14 0 0 VPWR VPWR x12_n15 sky130_fd_sc_hd__inv_1
X12_inv16 x12_n15 0 0 VPWR VPWR x12_n16 sky130_fd_sc_hd__inv_1
X12_inv17 x12_n16 0 0 VPWR VPWR x12_n17 sky130_fd_sc_hd__inv_1
X12_inv18 x12_n17 0 0 VPWR VPWR x12_n18 sky130_fd_sc_hd__inv_1
X12_inv19 x12_n18 0 0 VPWR VPWR x12_n19 sky130_fd_sc_hd__inv_1
X12_inv20 x12_n19 0 0 VPWR VPWR x12_n20 sky130_fd_sc_hd__inv_1
X12_inv21 x12_n20 0 0 VPWR VPWR x12_n21 sky130_fd_sc_hd__inv_1
X12_inv22 x12_n21 0 0 VPWR VPWR x12_n22 sky130_fd_sc_hd__inv_1
X12_inv23 x12_n22 0 0 VPWR VPWR x12_n23 sky130_fd_sc_hd__inv_1
X12_inv24 x12_n23 0 0 VPWR VPWR x12_n24 sky130_fd_sc_hd__inv_1
X12_inv25 x12_n24 0 0 VPWR VPWR x12_n25 sky130_fd_sc_hd__inv_1
X12_inv26 x12_n25 0 0 VPWR VPWR x12_n26 sky130_fd_sc_hd__inv_1
X12_inv27 x12_n26 0 0 VPWR VPWR x12_n27 sky130_fd_sc_hd__inv_1
X12_inv28 x12_n27 0 0 VPWR VPWR x12_n28 sky130_fd_sc_hd__inv_1
X12_inv29 x12_n28 0 0 VPWR VPWR x12_n29 sky130_fd_sc_hd__inv_1
X12_inv30 x12_n29 0 0 VPWR VPWR x12_n30 sky130_fd_sc_hd__inv_1
X12_buf x12_n15 0 0 VPWR VPWR x12_out sky130_fd_sc_hd__buf_1
C12_n0 x12_n0 0 5.537760e-16
C12_n1 x12_n1 0 3.015890e-16
C12_n2 x12_n2 0 3.629750e-16
C12_n3 x12_n3 0 2.454540e-16
C12_n4 x12_n4 0 4.635390e-16
C12_n5 x12_n5 0 3.514480e-16
C12_n6 x12_n6 0 3.710100e-16
C12_n7 x12_n7 0 3.605390e-16
C12_n8 x12_n8 0 1.073330e-16
C12_n9 x12_n9 0 1.263330e-16
C12_n10 x12_n10 0 1.711260e-16
C12_n11 x12_n11 0 5.971640e-16
C12_n12 x12_n12 0 1.639770e-16
C12_n13 x12_n13 0 1.067930e-16
C12_n14 x12_n14 0 1.561780e-16
C12_n15 x12_n15 0 1.003390e-15
C12_n16 x12_n16 0 2.125310e-16
C12_n17 x12_n17 0 2.125590e-16
C12_n18 x12_n18 0 7.368110e-16
C12_n19 x12_n19 0 2.144230e-16
C12_n20 x12_n20 0 2.144230e-16
C12_n21 x12_n21 0 5.848330e-16
C12_n22 x12_n22 0 1.068110e-16
C12_n23 x12_n23 0 4.298220e-16
C12_n24 x12_n24 0 2.589620e-16
C12_n25 x12_n25 0 6.777870e-16
C12_n26 x12_n26 0 2.226700e-16
C12_n27 x12_n27 0 7.143220e-16
C12_n28 x12_n28 0 1.462140e-15
C12_n29 x12_n29 0 7.519190e-16
C12_n30 x12_n30 0 5.658260e-16
C12_out x12_out 0 3.347230e-16
* --- RO 13 ---
X13_nand EN x13_n30 0 0 VPWR VPWR x13_n0 sky130_fd_sc_hd__nand2_1
X13_inv1 x13_n0 0 0 VPWR VPWR x13_n1 sky130_fd_sc_hd__inv_1
X13_inv2 x13_n1 0 0 VPWR VPWR x13_n2 sky130_fd_sc_hd__inv_1
X13_inv3 x13_n2 0 0 VPWR VPWR x13_n3 sky130_fd_sc_hd__inv_1
X13_inv4 x13_n3 0 0 VPWR VPWR x13_n4 sky130_fd_sc_hd__inv_1
X13_inv5 x13_n4 0 0 VPWR VPWR x13_n5 sky130_fd_sc_hd__inv_1
X13_inv6 x13_n5 0 0 VPWR VPWR x13_n6 sky130_fd_sc_hd__inv_1
X13_inv7 x13_n6 0 0 VPWR VPWR x13_n7 sky130_fd_sc_hd__inv_1
X13_inv8 x13_n7 0 0 VPWR VPWR x13_n8 sky130_fd_sc_hd__inv_1
X13_inv9 x13_n8 0 0 VPWR VPWR x13_n9 sky130_fd_sc_hd__inv_1
X13_inv10 x13_n9 0 0 VPWR VPWR x13_n10 sky130_fd_sc_hd__inv_1
X13_inv11 x13_n10 0 0 VPWR VPWR x13_n11 sky130_fd_sc_hd__inv_1
X13_inv12 x13_n11 0 0 VPWR VPWR x13_n12 sky130_fd_sc_hd__inv_1
X13_inv13 x13_n12 0 0 VPWR VPWR x13_n13 sky130_fd_sc_hd__inv_1
X13_inv14 x13_n13 0 0 VPWR VPWR x13_n14 sky130_fd_sc_hd__inv_1
X13_inv15 x13_n14 0 0 VPWR VPWR x13_n15 sky130_fd_sc_hd__inv_1
X13_inv16 x13_n15 0 0 VPWR VPWR x13_n16 sky130_fd_sc_hd__inv_1
X13_inv17 x13_n16 0 0 VPWR VPWR x13_n17 sky130_fd_sc_hd__inv_1
X13_inv18 x13_n17 0 0 VPWR VPWR x13_n18 sky130_fd_sc_hd__inv_1
X13_inv19 x13_n18 0 0 VPWR VPWR x13_n19 sky130_fd_sc_hd__inv_1
X13_inv20 x13_n19 0 0 VPWR VPWR x13_n20 sky130_fd_sc_hd__inv_1
X13_inv21 x13_n20 0 0 VPWR VPWR x13_n21 sky130_fd_sc_hd__inv_1
X13_inv22 x13_n21 0 0 VPWR VPWR x13_n22 sky130_fd_sc_hd__inv_1
X13_inv23 x13_n22 0 0 VPWR VPWR x13_n23 sky130_fd_sc_hd__inv_1
X13_inv24 x13_n23 0 0 VPWR VPWR x13_n24 sky130_fd_sc_hd__inv_1
X13_inv25 x13_n24 0 0 VPWR VPWR x13_n25 sky130_fd_sc_hd__inv_1
X13_inv26 x13_n25 0 0 VPWR VPWR x13_n26 sky130_fd_sc_hd__inv_1
X13_inv27 x13_n26 0 0 VPWR VPWR x13_n27 sky130_fd_sc_hd__inv_1
X13_inv28 x13_n27 0 0 VPWR VPWR x13_n28 sky130_fd_sc_hd__inv_1
X13_inv29 x13_n28 0 0 VPWR VPWR x13_n29 sky130_fd_sc_hd__inv_1
X13_inv30 x13_n29 0 0 VPWR VPWR x13_n30 sky130_fd_sc_hd__inv_1
X13_buf x13_n15 0 0 VPWR VPWR x13_out sky130_fd_sc_hd__buf_1
C13_n0 x13_n0 0 2.293320e-16
C13_n1 x13_n1 0 1.641850e-16
C13_n2 x13_n2 0 5.701150e-16
C13_n3 x13_n3 0 7.508740e-16
C13_n4 x13_n4 0 6.726080e-16
C13_n5 x13_n5 0 6.979980e-16
C13_n6 x13_n6 0 1.556730e-16
C13_n7 x13_n7 0 6.232750e-16
C13_n8 x13_n8 0 1.722270e-16
C13_n9 x13_n9 0 1.526920e-16
C13_n10 x13_n10 0 5.513520e-16
C13_n11 x13_n11 0 1.414150e-16
C13_n12 x13_n12 0 2.095580e-16
C13_n13 x13_n13 0 8.580290e-16
C13_n14 x13_n14 0 7.513510e-16
C13_n15 x13_n15 0 1.230730e-15
C13_n16 x13_n16 0 1.067930e-16
C13_n17 x13_n17 0 3.839470e-16
C13_n18 x13_n18 0 2.536540e-16
C13_n19 x13_n19 0 4.094570e-16
C13_n20 x13_n20 0 3.512830e-16
C13_n21 x13_n21 0 4.997400e-16
C13_n22 x13_n22 0 1.564940e-16
C13_n23 x13_n23 0 3.386390e-16
C13_n24 x13_n24 0 2.261320e-16
C13_n25 x13_n25 0 1.092810e-16
C13_n26 x13_n26 0 2.054090e-16
C13_n27 x13_n27 0 1.562140e-16
C13_n28 x13_n28 0 6.338900e-16
C13_n29 x13_n29 0 1.556730e-16
C13_n30 x13_n30 0 9.600310e-17
C13_out x13_out 0 1.763070e-16
* --- RO 14 ---
X14_nand EN x14_n30 0 0 VPWR VPWR x14_n0 sky130_fd_sc_hd__nand2_1
X14_inv1 x14_n0 0 0 VPWR VPWR x14_n1 sky130_fd_sc_hd__inv_1
X14_inv2 x14_n1 0 0 VPWR VPWR x14_n2 sky130_fd_sc_hd__inv_1
X14_inv3 x14_n2 0 0 VPWR VPWR x14_n3 sky130_fd_sc_hd__inv_1
X14_inv4 x14_n3 0 0 VPWR VPWR x14_n4 sky130_fd_sc_hd__inv_1
X14_inv5 x14_n4 0 0 VPWR VPWR x14_n5 sky130_fd_sc_hd__inv_1
X14_inv6 x14_n5 0 0 VPWR VPWR x14_n6 sky130_fd_sc_hd__inv_1
X14_inv7 x14_n6 0 0 VPWR VPWR x14_n7 sky130_fd_sc_hd__inv_1
X14_inv8 x14_n7 0 0 VPWR VPWR x14_n8 sky130_fd_sc_hd__inv_1
X14_inv9 x14_n8 0 0 VPWR VPWR x14_n9 sky130_fd_sc_hd__inv_1
X14_inv10 x14_n9 0 0 VPWR VPWR x14_n10 sky130_fd_sc_hd__inv_1
X14_inv11 x14_n10 0 0 VPWR VPWR x14_n11 sky130_fd_sc_hd__inv_1
X14_inv12 x14_n11 0 0 VPWR VPWR x14_n12 sky130_fd_sc_hd__inv_1
X14_inv13 x14_n12 0 0 VPWR VPWR x14_n13 sky130_fd_sc_hd__inv_1
X14_inv14 x14_n13 0 0 VPWR VPWR x14_n14 sky130_fd_sc_hd__inv_1
X14_inv15 x14_n14 0 0 VPWR VPWR x14_n15 sky130_fd_sc_hd__inv_1
X14_inv16 x14_n15 0 0 VPWR VPWR x14_n16 sky130_fd_sc_hd__inv_1
X14_inv17 x14_n16 0 0 VPWR VPWR x14_n17 sky130_fd_sc_hd__inv_1
X14_inv18 x14_n17 0 0 VPWR VPWR x14_n18 sky130_fd_sc_hd__inv_1
X14_inv19 x14_n18 0 0 VPWR VPWR x14_n19 sky130_fd_sc_hd__inv_1
X14_inv20 x14_n19 0 0 VPWR VPWR x14_n20 sky130_fd_sc_hd__inv_1
X14_inv21 x14_n20 0 0 VPWR VPWR x14_n21 sky130_fd_sc_hd__inv_1
X14_inv22 x14_n21 0 0 VPWR VPWR x14_n22 sky130_fd_sc_hd__inv_1
X14_inv23 x14_n22 0 0 VPWR VPWR x14_n23 sky130_fd_sc_hd__inv_1
X14_inv24 x14_n23 0 0 VPWR VPWR x14_n24 sky130_fd_sc_hd__inv_1
X14_inv25 x14_n24 0 0 VPWR VPWR x14_n25 sky130_fd_sc_hd__inv_1
X14_inv26 x14_n25 0 0 VPWR VPWR x14_n26 sky130_fd_sc_hd__inv_1
X14_inv27 x14_n26 0 0 VPWR VPWR x14_n27 sky130_fd_sc_hd__inv_1
X14_inv28 x14_n27 0 0 VPWR VPWR x14_n28 sky130_fd_sc_hd__inv_1
X14_inv29 x14_n28 0 0 VPWR VPWR x14_n29 sky130_fd_sc_hd__inv_1
X14_inv30 x14_n29 0 0 VPWR VPWR x14_n30 sky130_fd_sc_hd__inv_1
X14_buf x14_n15 0 0 VPWR VPWR x14_out sky130_fd_sc_hd__buf_1
C14_n0 x14_n0 0 4.784900e-16
C14_n1 x14_n1 0 1.067930e-16
C14_n2 x14_n2 0 1.067930e-16
C14_n3 x14_n3 0 1.067930e-16
C14_n4 x14_n4 0 1.067930e-16
C14_n5 x14_n5 0 1.067930e-16
C14_n6 x14_n6 0 1.072980e-16
C14_n7 x14_n7 0 1.093170e-16
C14_n8 x14_n8 0 1.637010e-16
C14_n9 x14_n9 0 4.165620e-16
C14_n10 x14_n10 0 7.168170e-16
C14_n11 x14_n11 0 1.250960e-16
C14_n12 x14_n12 0 2.333890e-16
C14_n13 x14_n13 0 3.884120e-16
C14_n14 x14_n14 0 1.628300e-16
C14_n15 x14_n15 0 1.786220e-15
C14_n16 x14_n16 0 8.373880e-16
C14_n17 x14_n17 0 5.740120e-16
C14_n18 x14_n18 0 4.565220e-16
C14_n19 x14_n19 0 1.372890e-16
C14_n20 x14_n20 0 1.262580e-16
C14_n21 x14_n21 0 1.360040e-16
C14_n22 x14_n22 0 1.629830e-16
C14_n23 x14_n23 0 6.275140e-16
C14_n24 x14_n24 0 2.125310e-16
C14_n25 x14_n25 0 2.125310e-16
C14_n26 x14_n26 0 2.125310e-16
C14_n27 x14_n27 0 2.125310e-16
C14_n28 x14_n28 0 3.628050e-16
C14_n29 x14_n29 0 2.321710e-16
C14_n30 x14_n30 0 1.033140e-16
C14_out x14_out 0 5.119740e-16
* --- RO 15 ---
X15_nand EN x15_n30 0 0 VPWR VPWR x15_n0 sky130_fd_sc_hd__nand2_1
X15_inv1 x15_n0 0 0 VPWR VPWR x15_n1 sky130_fd_sc_hd__inv_1
X15_inv2 x15_n1 0 0 VPWR VPWR x15_n2 sky130_fd_sc_hd__inv_1
X15_inv3 x15_n2 0 0 VPWR VPWR x15_n3 sky130_fd_sc_hd__inv_1
X15_inv4 x15_n3 0 0 VPWR VPWR x15_n4 sky130_fd_sc_hd__inv_1
X15_inv5 x15_n4 0 0 VPWR VPWR x15_n5 sky130_fd_sc_hd__inv_1
X15_inv6 x15_n5 0 0 VPWR VPWR x15_n6 sky130_fd_sc_hd__inv_1
X15_inv7 x15_n6 0 0 VPWR VPWR x15_n7 sky130_fd_sc_hd__inv_1
X15_inv8 x15_n7 0 0 VPWR VPWR x15_n8 sky130_fd_sc_hd__inv_1
X15_inv9 x15_n8 0 0 VPWR VPWR x15_n9 sky130_fd_sc_hd__inv_1
X15_inv10 x15_n9 0 0 VPWR VPWR x15_n10 sky130_fd_sc_hd__inv_1
X15_inv11 x15_n10 0 0 VPWR VPWR x15_n11 sky130_fd_sc_hd__inv_1
X15_inv12 x15_n11 0 0 VPWR VPWR x15_n12 sky130_fd_sc_hd__inv_1
X15_inv13 x15_n12 0 0 VPWR VPWR x15_n13 sky130_fd_sc_hd__inv_1
X15_inv14 x15_n13 0 0 VPWR VPWR x15_n14 sky130_fd_sc_hd__inv_1
X15_inv15 x15_n14 0 0 VPWR VPWR x15_n15 sky130_fd_sc_hd__inv_1
X15_inv16 x15_n15 0 0 VPWR VPWR x15_n16 sky130_fd_sc_hd__inv_1
X15_inv17 x15_n16 0 0 VPWR VPWR x15_n17 sky130_fd_sc_hd__inv_1
X15_inv18 x15_n17 0 0 VPWR VPWR x15_n18 sky130_fd_sc_hd__inv_1
X15_inv19 x15_n18 0 0 VPWR VPWR x15_n19 sky130_fd_sc_hd__inv_1
X15_inv20 x15_n19 0 0 VPWR VPWR x15_n20 sky130_fd_sc_hd__inv_1
X15_inv21 x15_n20 0 0 VPWR VPWR x15_n21 sky130_fd_sc_hd__inv_1
X15_inv22 x15_n21 0 0 VPWR VPWR x15_n22 sky130_fd_sc_hd__inv_1
X15_inv23 x15_n22 0 0 VPWR VPWR x15_n23 sky130_fd_sc_hd__inv_1
X15_inv24 x15_n23 0 0 VPWR VPWR x15_n24 sky130_fd_sc_hd__inv_1
X15_inv25 x15_n24 0 0 VPWR VPWR x15_n25 sky130_fd_sc_hd__inv_1
X15_inv26 x15_n25 0 0 VPWR VPWR x15_n26 sky130_fd_sc_hd__inv_1
X15_inv27 x15_n26 0 0 VPWR VPWR x15_n27 sky130_fd_sc_hd__inv_1
X15_inv28 x15_n27 0 0 VPWR VPWR x15_n28 sky130_fd_sc_hd__inv_1
X15_inv29 x15_n28 0 0 VPWR VPWR x15_n29 sky130_fd_sc_hd__inv_1
X15_inv30 x15_n29 0 0 VPWR VPWR x15_n30 sky130_fd_sc_hd__inv_1
X15_buf x15_n15 0 0 VPWR VPWR x15_out sky130_fd_sc_hd__buf_1
C15_n0 x15_n0 0 3.193810e-16
C15_n1 x15_n1 0 8.784710e-16
C15_n2 x15_n2 0 2.028850e-16
C15_n3 x15_n3 0 5.543240e-16
C15_n4 x15_n4 0 1.440810e-16
C15_n5 x15_n5 0 1.136000e-16
C15_n6 x15_n6 0 5.123190e-16
C15_n7 x15_n7 0 3.098090e-16
C15_n8 x15_n8 0 2.125310e-16
C15_n9 x15_n9 0 2.992350e-16
C15_n10 x15_n10 0 6.142120e-16
C15_n11 x15_n11 0 4.808590e-16
C15_n12 x15_n12 0 1.761310e-16
C15_n13 x15_n13 0 4.902770e-16
C15_n14 x15_n14 0 3.391210e-16
C15_n15 x15_n15 0 8.640360e-16
C15_n16 x15_n16 0 1.556730e-16
C15_n17 x15_n17 0 3.098490e-16
C15_n18 x15_n18 0 3.479050e-16
C15_n19 x15_n19 0 5.971110e-16
C15_n20 x15_n20 0 7.872110e-16
C15_n21 x15_n21 0 8.780690e-16
C15_n22 x15_n22 0 4.156920e-16
C15_n23 x15_n23 0 1.073340e-16
C15_n24 x15_n24 0 1.581620e-16
C15_n25 x15_n25 0 3.366480e-16
C15_n26 x15_n26 0 3.335060e-16
C15_n27 x15_n27 0 3.911360e-16
C15_n28 x15_n28 0 5.667960e-16
C15_n29 x15_n29 0 2.080430e-16
C15_n30 x15_n30 0 1.701000e-16
C15_out x15_out 0 9.303570e-16
* --- RO 16 ---
X16_nand EN x16_n30 0 0 VPWR VPWR x16_n0 sky130_fd_sc_hd__nand2_1
X16_inv1 x16_n0 0 0 VPWR VPWR x16_n1 sky130_fd_sc_hd__inv_1
X16_inv2 x16_n1 0 0 VPWR VPWR x16_n2 sky130_fd_sc_hd__inv_1
X16_inv3 x16_n2 0 0 VPWR VPWR x16_n3 sky130_fd_sc_hd__inv_1
X16_inv4 x16_n3 0 0 VPWR VPWR x16_n4 sky130_fd_sc_hd__inv_1
X16_inv5 x16_n4 0 0 VPWR VPWR x16_n5 sky130_fd_sc_hd__inv_1
X16_inv6 x16_n5 0 0 VPWR VPWR x16_n6 sky130_fd_sc_hd__inv_1
X16_inv7 x16_n6 0 0 VPWR VPWR x16_n7 sky130_fd_sc_hd__inv_1
X16_inv8 x16_n7 0 0 VPWR VPWR x16_n8 sky130_fd_sc_hd__inv_1
X16_inv9 x16_n8 0 0 VPWR VPWR x16_n9 sky130_fd_sc_hd__inv_1
X16_inv10 x16_n9 0 0 VPWR VPWR x16_n10 sky130_fd_sc_hd__inv_1
X16_inv11 x16_n10 0 0 VPWR VPWR x16_n11 sky130_fd_sc_hd__inv_1
X16_inv12 x16_n11 0 0 VPWR VPWR x16_n12 sky130_fd_sc_hd__inv_1
X16_inv13 x16_n12 0 0 VPWR VPWR x16_n13 sky130_fd_sc_hd__inv_1
X16_inv14 x16_n13 0 0 VPWR VPWR x16_n14 sky130_fd_sc_hd__inv_1
X16_inv15 x16_n14 0 0 VPWR VPWR x16_n15 sky130_fd_sc_hd__inv_1
X16_inv16 x16_n15 0 0 VPWR VPWR x16_n16 sky130_fd_sc_hd__inv_1
X16_inv17 x16_n16 0 0 VPWR VPWR x16_n17 sky130_fd_sc_hd__inv_1
X16_inv18 x16_n17 0 0 VPWR VPWR x16_n18 sky130_fd_sc_hd__inv_1
X16_inv19 x16_n18 0 0 VPWR VPWR x16_n19 sky130_fd_sc_hd__inv_1
X16_inv20 x16_n19 0 0 VPWR VPWR x16_n20 sky130_fd_sc_hd__inv_1
X16_inv21 x16_n20 0 0 VPWR VPWR x16_n21 sky130_fd_sc_hd__inv_1
X16_inv22 x16_n21 0 0 VPWR VPWR x16_n22 sky130_fd_sc_hd__inv_1
X16_inv23 x16_n22 0 0 VPWR VPWR x16_n23 sky130_fd_sc_hd__inv_1
X16_inv24 x16_n23 0 0 VPWR VPWR x16_n24 sky130_fd_sc_hd__inv_1
X16_inv25 x16_n24 0 0 VPWR VPWR x16_n25 sky130_fd_sc_hd__inv_1
X16_inv26 x16_n25 0 0 VPWR VPWR x16_n26 sky130_fd_sc_hd__inv_1
X16_inv27 x16_n26 0 0 VPWR VPWR x16_n27 sky130_fd_sc_hd__inv_1
X16_inv28 x16_n27 0 0 VPWR VPWR x16_n28 sky130_fd_sc_hd__inv_1
X16_inv29 x16_n28 0 0 VPWR VPWR x16_n29 sky130_fd_sc_hd__inv_1
X16_inv30 x16_n29 0 0 VPWR VPWR x16_n30 sky130_fd_sc_hd__inv_1
X16_buf x16_n15 0 0 VPWR VPWR x16_out sky130_fd_sc_hd__buf_1
C16_n0 x16_n0 0 1.871800e-16
C16_n1 x16_n1 0 1.069210e-16
C16_n2 x16_n2 0 1.070650e-16
C16_n3 x16_n3 0 1.069360e-16
C16_n4 x16_n4 0 8.597620e-16
C16_n5 x16_n5 0 2.198420e-16
C16_n6 x16_n6 0 1.643330e-16
C16_n7 x16_n7 0 1.067930e-16
C16_n8 x16_n8 0 1.168900e-16
C16_n9 x16_n9 0 1.570420e-16
C16_n10 x16_n10 0 5.619940e-16
C16_n11 x16_n11 0 1.673980e-16
C16_n12 x16_n12 0 4.069200e-16
C16_n13 x16_n13 0 1.696650e-16
C16_n14 x16_n14 0 3.797760e-16
C16_n15 x16_n15 0 6.165680e-16
C16_n16 x16_n16 0 1.231780e-16
C16_n17 x16_n17 0 1.629830e-16
C16_n18 x16_n18 0 6.409080e-16
C16_n19 x16_n19 0 1.165160e-16
C16_n20 x16_n20 0 7.050720e-16
C16_n21 x16_n21 0 1.569010e-16
C16_n22 x16_n22 0 4.339570e-16
C16_n23 x16_n23 0 1.262230e-16
C16_n24 x16_n24 0 1.825290e-16
C16_n25 x16_n25 0 3.285090e-16
C16_n26 x16_n26 0 5.841940e-16
C16_n27 x16_n27 0 1.187610e-16
C16_n28 x16_n28 0 4.147240e-16
C16_n29 x16_n29 0 1.067930e-16
C16_n30 x16_n30 0 2.642150e-16
C16_out x16_out 0 3.632190e-15
* --- RO 17 ---
X17_nand EN x17_n30 0 0 VPWR VPWR x17_n0 sky130_fd_sc_hd__nand2_1
X17_inv1 x17_n0 0 0 VPWR VPWR x17_n1 sky130_fd_sc_hd__inv_1
X17_inv2 x17_n1 0 0 VPWR VPWR x17_n2 sky130_fd_sc_hd__inv_1
X17_inv3 x17_n2 0 0 VPWR VPWR x17_n3 sky130_fd_sc_hd__inv_1
X17_inv4 x17_n3 0 0 VPWR VPWR x17_n4 sky130_fd_sc_hd__inv_1
X17_inv5 x17_n4 0 0 VPWR VPWR x17_n5 sky130_fd_sc_hd__inv_1
X17_inv6 x17_n5 0 0 VPWR VPWR x17_n6 sky130_fd_sc_hd__inv_1
X17_inv7 x17_n6 0 0 VPWR VPWR x17_n7 sky130_fd_sc_hd__inv_1
X17_inv8 x17_n7 0 0 VPWR VPWR x17_n8 sky130_fd_sc_hd__inv_1
X17_inv9 x17_n8 0 0 VPWR VPWR x17_n9 sky130_fd_sc_hd__inv_1
X17_inv10 x17_n9 0 0 VPWR VPWR x17_n10 sky130_fd_sc_hd__inv_1
X17_inv11 x17_n10 0 0 VPWR VPWR x17_n11 sky130_fd_sc_hd__inv_1
X17_inv12 x17_n11 0 0 VPWR VPWR x17_n12 sky130_fd_sc_hd__inv_1
X17_inv13 x17_n12 0 0 VPWR VPWR x17_n13 sky130_fd_sc_hd__inv_1
X17_inv14 x17_n13 0 0 VPWR VPWR x17_n14 sky130_fd_sc_hd__inv_1
X17_inv15 x17_n14 0 0 VPWR VPWR x17_n15 sky130_fd_sc_hd__inv_1
X17_inv16 x17_n15 0 0 VPWR VPWR x17_n16 sky130_fd_sc_hd__inv_1
X17_inv17 x17_n16 0 0 VPWR VPWR x17_n17 sky130_fd_sc_hd__inv_1
X17_inv18 x17_n17 0 0 VPWR VPWR x17_n18 sky130_fd_sc_hd__inv_1
X17_inv19 x17_n18 0 0 VPWR VPWR x17_n19 sky130_fd_sc_hd__inv_1
X17_inv20 x17_n19 0 0 VPWR VPWR x17_n20 sky130_fd_sc_hd__inv_1
X17_inv21 x17_n20 0 0 VPWR VPWR x17_n21 sky130_fd_sc_hd__inv_1
X17_inv22 x17_n21 0 0 VPWR VPWR x17_n22 sky130_fd_sc_hd__inv_1
X17_inv23 x17_n22 0 0 VPWR VPWR x17_n23 sky130_fd_sc_hd__inv_1
X17_inv24 x17_n23 0 0 VPWR VPWR x17_n24 sky130_fd_sc_hd__inv_1
X17_inv25 x17_n24 0 0 VPWR VPWR x17_n25 sky130_fd_sc_hd__inv_1
X17_inv26 x17_n25 0 0 VPWR VPWR x17_n26 sky130_fd_sc_hd__inv_1
X17_inv27 x17_n26 0 0 VPWR VPWR x17_n27 sky130_fd_sc_hd__inv_1
X17_inv28 x17_n27 0 0 VPWR VPWR x17_n28 sky130_fd_sc_hd__inv_1
X17_inv29 x17_n28 0 0 VPWR VPWR x17_n29 sky130_fd_sc_hd__inv_1
X17_inv30 x17_n29 0 0 VPWR VPWR x17_n30 sky130_fd_sc_hd__inv_1
X17_buf x17_n15 0 0 VPWR VPWR x17_out sky130_fd_sc_hd__buf_1
C17_n0 x17_n0 0 2.304340e-16
C17_n1 x17_n1 0 3.752360e-16
C17_n2 x17_n2 0 2.512180e-16
C17_n3 x17_n3 0 3.484560e-16
C17_n4 x17_n4 0 2.840000e-16
C17_n5 x17_n5 0 8.168200e-16
C17_n6 x17_n6 0 1.696650e-16
C17_n7 x17_n7 0 4.484350e-16
C17_n8 x17_n8 0 7.506740e-16
C17_n9 x17_n9 0 2.203370e-16
C17_n10 x17_n10 0 5.571100e-16
C17_n11 x17_n11 0 1.067930e-16
C17_n12 x17_n12 0 1.067930e-16
C17_n13 x17_n13 0 1.067930e-16
C17_n14 x17_n14 0 1.067930e-16
C17_n15 x17_n15 0 1.211950e-15
C17_n16 x17_n16 0 1.629830e-16
C17_n17 x17_n17 0 5.000030e-16
C17_n18 x17_n18 0 1.628300e-16
C17_n19 x17_n19 0 2.421980e-16
C17_n20 x17_n20 0 6.020740e-16
C17_n21 x17_n21 0 7.425340e-16
C17_n22 x17_n22 0 1.067930e-16
C17_n23 x17_n23 0 3.789120e-16
C17_n24 x17_n24 0 6.166030e-16
C17_n25 x17_n25 0 1.747980e-16
C17_n26 x17_n26 0 3.826930e-16
C17_n27 x17_n27 0 1.937130e-16
C17_n28 x17_n28 0 1.710520e-16
C17_n29 x17_n29 0 5.084460e-16
C17_n30 x17_n30 0 9.068550e-17
C17_out x17_out 0 2.226560e-16
* --- RO 18 ---
X18_nand EN x18_n30 0 0 VPWR VPWR x18_n0 sky130_fd_sc_hd__nand2_1
X18_inv1 x18_n0 0 0 VPWR VPWR x18_n1 sky130_fd_sc_hd__inv_1
X18_inv2 x18_n1 0 0 VPWR VPWR x18_n2 sky130_fd_sc_hd__inv_1
X18_inv3 x18_n2 0 0 VPWR VPWR x18_n3 sky130_fd_sc_hd__inv_1
X18_inv4 x18_n3 0 0 VPWR VPWR x18_n4 sky130_fd_sc_hd__inv_1
X18_inv5 x18_n4 0 0 VPWR VPWR x18_n5 sky130_fd_sc_hd__inv_1
X18_inv6 x18_n5 0 0 VPWR VPWR x18_n6 sky130_fd_sc_hd__inv_1
X18_inv7 x18_n6 0 0 VPWR VPWR x18_n7 sky130_fd_sc_hd__inv_1
X18_inv8 x18_n7 0 0 VPWR VPWR x18_n8 sky130_fd_sc_hd__inv_1
X18_inv9 x18_n8 0 0 VPWR VPWR x18_n9 sky130_fd_sc_hd__inv_1
X18_inv10 x18_n9 0 0 VPWR VPWR x18_n10 sky130_fd_sc_hd__inv_1
X18_inv11 x18_n10 0 0 VPWR VPWR x18_n11 sky130_fd_sc_hd__inv_1
X18_inv12 x18_n11 0 0 VPWR VPWR x18_n12 sky130_fd_sc_hd__inv_1
X18_inv13 x18_n12 0 0 VPWR VPWR x18_n13 sky130_fd_sc_hd__inv_1
X18_inv14 x18_n13 0 0 VPWR VPWR x18_n14 sky130_fd_sc_hd__inv_1
X18_inv15 x18_n14 0 0 VPWR VPWR x18_n15 sky130_fd_sc_hd__inv_1
X18_inv16 x18_n15 0 0 VPWR VPWR x18_n16 sky130_fd_sc_hd__inv_1
X18_inv17 x18_n16 0 0 VPWR VPWR x18_n17 sky130_fd_sc_hd__inv_1
X18_inv18 x18_n17 0 0 VPWR VPWR x18_n18 sky130_fd_sc_hd__inv_1
X18_inv19 x18_n18 0 0 VPWR VPWR x18_n19 sky130_fd_sc_hd__inv_1
X18_inv20 x18_n19 0 0 VPWR VPWR x18_n20 sky130_fd_sc_hd__inv_1
X18_inv21 x18_n20 0 0 VPWR VPWR x18_n21 sky130_fd_sc_hd__inv_1
X18_inv22 x18_n21 0 0 VPWR VPWR x18_n22 sky130_fd_sc_hd__inv_1
X18_inv23 x18_n22 0 0 VPWR VPWR x18_n23 sky130_fd_sc_hd__inv_1
X18_inv24 x18_n23 0 0 VPWR VPWR x18_n24 sky130_fd_sc_hd__inv_1
X18_inv25 x18_n24 0 0 VPWR VPWR x18_n25 sky130_fd_sc_hd__inv_1
X18_inv26 x18_n25 0 0 VPWR VPWR x18_n26 sky130_fd_sc_hd__inv_1
X18_inv27 x18_n26 0 0 VPWR VPWR x18_n27 sky130_fd_sc_hd__inv_1
X18_inv28 x18_n27 0 0 VPWR VPWR x18_n28 sky130_fd_sc_hd__inv_1
X18_inv29 x18_n28 0 0 VPWR VPWR x18_n29 sky130_fd_sc_hd__inv_1
X18_inv30 x18_n29 0 0 VPWR VPWR x18_n30 sky130_fd_sc_hd__inv_1
X18_buf x18_n15 0 0 VPWR VPWR x18_out sky130_fd_sc_hd__buf_1
C18_n0 x18_n0 0 3.329780e-16
C18_n1 x18_n1 0 1.640130e-16
C18_n2 x18_n2 0 4.660150e-16
C18_n3 x18_n3 0 1.255900e-15
C18_n4 x18_n4 0 3.319460e-16
C18_n5 x18_n5 0 2.444460e-16
C18_n6 x18_n6 0 1.070650e-16
C18_n7 x18_n7 0 1.070650e-16
C18_n8 x18_n8 0 1.071000e-16
C18_n9 x18_n9 0 1.582040e-16
C18_n10 x18_n10 0 5.157760e-16
C18_n11 x18_n11 0 1.564940e-16
C18_n12 x18_n12 0 1.564940e-16
C18_n13 x18_n13 0 1.564940e-16
C18_n14 x18_n14 0 1.564940e-16
C18_n15 x18_n15 0 1.237010e-15
C18_n16 x18_n16 0 3.368020e-16
C18_n17 x18_n17 0 2.303370e-16
C18_n18 x18_n18 0 1.070650e-16
C18_n19 x18_n19 0 1.161530e-16
C18_n20 x18_n20 0 1.263330e-16
C18_n21 x18_n21 0 1.081540e-16
C18_n22 x18_n22 0 1.067930e-16
C18_n23 x18_n23 0 1.602440e-16
C18_n24 x18_n24 0 3.967590e-16
C18_n25 x18_n25 0 1.067930e-16
C18_n26 x18_n26 0 1.067930e-16
C18_n27 x18_n27 0 6.888940e-16
C18_n28 x18_n28 0 1.067930e-16
C18_n29 x18_n29 0 1.067930e-16
C18_n30 x18_n30 0 3.272280e-16
C18_out x18_out 0 4.858260e-16
* --- RO 19 ---
X19_nand EN x19_n30 0 0 VPWR VPWR x19_n0 sky130_fd_sc_hd__nand2_1
X19_inv1 x19_n0 0 0 VPWR VPWR x19_n1 sky130_fd_sc_hd__inv_1
X19_inv2 x19_n1 0 0 VPWR VPWR x19_n2 sky130_fd_sc_hd__inv_1
X19_inv3 x19_n2 0 0 VPWR VPWR x19_n3 sky130_fd_sc_hd__inv_1
X19_inv4 x19_n3 0 0 VPWR VPWR x19_n4 sky130_fd_sc_hd__inv_1
X19_inv5 x19_n4 0 0 VPWR VPWR x19_n5 sky130_fd_sc_hd__inv_1
X19_inv6 x19_n5 0 0 VPWR VPWR x19_n6 sky130_fd_sc_hd__inv_1
X19_inv7 x19_n6 0 0 VPWR VPWR x19_n7 sky130_fd_sc_hd__inv_1
X19_inv8 x19_n7 0 0 VPWR VPWR x19_n8 sky130_fd_sc_hd__inv_1
X19_inv9 x19_n8 0 0 VPWR VPWR x19_n9 sky130_fd_sc_hd__inv_1
X19_inv10 x19_n9 0 0 VPWR VPWR x19_n10 sky130_fd_sc_hd__inv_1
X19_inv11 x19_n10 0 0 VPWR VPWR x19_n11 sky130_fd_sc_hd__inv_1
X19_inv12 x19_n11 0 0 VPWR VPWR x19_n12 sky130_fd_sc_hd__inv_1
X19_inv13 x19_n12 0 0 VPWR VPWR x19_n13 sky130_fd_sc_hd__inv_1
X19_inv14 x19_n13 0 0 VPWR VPWR x19_n14 sky130_fd_sc_hd__inv_1
X19_inv15 x19_n14 0 0 VPWR VPWR x19_n15 sky130_fd_sc_hd__inv_1
X19_inv16 x19_n15 0 0 VPWR VPWR x19_n16 sky130_fd_sc_hd__inv_1
X19_inv17 x19_n16 0 0 VPWR VPWR x19_n17 sky130_fd_sc_hd__inv_1
X19_inv18 x19_n17 0 0 VPWR VPWR x19_n18 sky130_fd_sc_hd__inv_1
X19_inv19 x19_n18 0 0 VPWR VPWR x19_n19 sky130_fd_sc_hd__inv_1
X19_inv20 x19_n19 0 0 VPWR VPWR x19_n20 sky130_fd_sc_hd__inv_1
X19_inv21 x19_n20 0 0 VPWR VPWR x19_n21 sky130_fd_sc_hd__inv_1
X19_inv22 x19_n21 0 0 VPWR VPWR x19_n22 sky130_fd_sc_hd__inv_1
X19_inv23 x19_n22 0 0 VPWR VPWR x19_n23 sky130_fd_sc_hd__inv_1
X19_inv24 x19_n23 0 0 VPWR VPWR x19_n24 sky130_fd_sc_hd__inv_1
X19_inv25 x19_n24 0 0 VPWR VPWR x19_n25 sky130_fd_sc_hd__inv_1
X19_inv26 x19_n25 0 0 VPWR VPWR x19_n26 sky130_fd_sc_hd__inv_1
X19_inv27 x19_n26 0 0 VPWR VPWR x19_n27 sky130_fd_sc_hd__inv_1
X19_inv28 x19_n27 0 0 VPWR VPWR x19_n28 sky130_fd_sc_hd__inv_1
X19_inv29 x19_n28 0 0 VPWR VPWR x19_n29 sky130_fd_sc_hd__inv_1
X19_inv30 x19_n29 0 0 VPWR VPWR x19_n30 sky130_fd_sc_hd__inv_1
X19_buf x19_n15 0 0 VPWR VPWR x19_out sky130_fd_sc_hd__buf_1
C19_n0 x19_n0 0 2.697350e-16
C19_n1 x19_n1 0 1.370650e-16
C19_n2 x19_n2 0 1.370650e-16
C19_n3 x19_n3 0 5.860380e-16
C19_n4 x19_n4 0 3.284820e-16
C19_n5 x19_n5 0 7.701070e-16
C19_n6 x19_n6 0 5.665760e-16
C19_n7 x19_n7 0 2.714140e-16
C19_n8 x19_n8 0 6.304580e-16
C19_n9 x19_n9 0 1.552170e-16
C19_n10 x19_n10 0 3.427840e-16
C19_n11 x19_n11 0 2.256130e-16
C19_n12 x19_n12 0 4.281680e-16
C19_n13 x19_n13 0 1.233470e-16
C19_n14 x19_n14 0 1.067930e-16
C19_n15 x19_n15 0 5.108580e-16
C19_n16 x19_n16 0 1.067930e-16
C19_n17 x19_n17 0 1.067930e-16
C19_n18 x19_n18 0 1.067930e-16
C19_n19 x19_n19 0 1.526920e-16
C19_n20 x19_n20 0 4.625420e-16
C19_n21 x19_n21 0 6.807720e-16
C19_n22 x19_n22 0 1.251800e-16
C19_n23 x19_n23 0 1.250960e-16
C19_n24 x19_n24 0 3.445170e-16
C19_n25 x19_n25 0 1.564940e-16
C19_n26 x19_n26 0 1.564940e-16
C19_n27 x19_n27 0 1.564940e-16
C19_n28 x19_n28 0 2.017430e-16
C19_n29 x19_n29 0 6.899670e-16
C19_n30 x19_n30 0 8.325750e-16
C19_out x19_out 0 6.163930e-16
* --- RO 20 ---
X20_nand EN x20_n30 0 0 VPWR VPWR x20_n0 sky130_fd_sc_hd__nand2_1
X20_inv1 x20_n0 0 0 VPWR VPWR x20_n1 sky130_fd_sc_hd__inv_1
X20_inv2 x20_n1 0 0 VPWR VPWR x20_n2 sky130_fd_sc_hd__inv_1
X20_inv3 x20_n2 0 0 VPWR VPWR x20_n3 sky130_fd_sc_hd__inv_1
X20_inv4 x20_n3 0 0 VPWR VPWR x20_n4 sky130_fd_sc_hd__inv_1
X20_inv5 x20_n4 0 0 VPWR VPWR x20_n5 sky130_fd_sc_hd__inv_1
X20_inv6 x20_n5 0 0 VPWR VPWR x20_n6 sky130_fd_sc_hd__inv_1
X20_inv7 x20_n6 0 0 VPWR VPWR x20_n7 sky130_fd_sc_hd__inv_1
X20_inv8 x20_n7 0 0 VPWR VPWR x20_n8 sky130_fd_sc_hd__inv_1
X20_inv9 x20_n8 0 0 VPWR VPWR x20_n9 sky130_fd_sc_hd__inv_1
X20_inv10 x20_n9 0 0 VPWR VPWR x20_n10 sky130_fd_sc_hd__inv_1
X20_inv11 x20_n10 0 0 VPWR VPWR x20_n11 sky130_fd_sc_hd__inv_1
X20_inv12 x20_n11 0 0 VPWR VPWR x20_n12 sky130_fd_sc_hd__inv_1
X20_inv13 x20_n12 0 0 VPWR VPWR x20_n13 sky130_fd_sc_hd__inv_1
X20_inv14 x20_n13 0 0 VPWR VPWR x20_n14 sky130_fd_sc_hd__inv_1
X20_inv15 x20_n14 0 0 VPWR VPWR x20_n15 sky130_fd_sc_hd__inv_1
X20_inv16 x20_n15 0 0 VPWR VPWR x20_n16 sky130_fd_sc_hd__inv_1
X20_inv17 x20_n16 0 0 VPWR VPWR x20_n17 sky130_fd_sc_hd__inv_1
X20_inv18 x20_n17 0 0 VPWR VPWR x20_n18 sky130_fd_sc_hd__inv_1
X20_inv19 x20_n18 0 0 VPWR VPWR x20_n19 sky130_fd_sc_hd__inv_1
X20_inv20 x20_n19 0 0 VPWR VPWR x20_n20 sky130_fd_sc_hd__inv_1
X20_inv21 x20_n20 0 0 VPWR VPWR x20_n21 sky130_fd_sc_hd__inv_1
X20_inv22 x20_n21 0 0 VPWR VPWR x20_n22 sky130_fd_sc_hd__inv_1
X20_inv23 x20_n22 0 0 VPWR VPWR x20_n23 sky130_fd_sc_hd__inv_1
X20_inv24 x20_n23 0 0 VPWR VPWR x20_n24 sky130_fd_sc_hd__inv_1
X20_inv25 x20_n24 0 0 VPWR VPWR x20_n25 sky130_fd_sc_hd__inv_1
X20_inv26 x20_n25 0 0 VPWR VPWR x20_n26 sky130_fd_sc_hd__inv_1
X20_inv27 x20_n26 0 0 VPWR VPWR x20_n27 sky130_fd_sc_hd__inv_1
X20_inv28 x20_n27 0 0 VPWR VPWR x20_n28 sky130_fd_sc_hd__inv_1
X20_inv29 x20_n28 0 0 VPWR VPWR x20_n29 sky130_fd_sc_hd__inv_1
X20_inv30 x20_n29 0 0 VPWR VPWR x20_n30 sky130_fd_sc_hd__inv_1
X20_buf x20_n15 0 0 VPWR VPWR x20_out sky130_fd_sc_hd__buf_1
C20_n0 x20_n0 0 3.917970e-16
C20_n1 x20_n1 0 2.621760e-16
C20_n2 x20_n2 0 5.196920e-16
C20_n3 x20_n3 0 4.077480e-16
C20_n4 x20_n4 0 6.577480e-16
C20_n5 x20_n5 0 7.702880e-16
C20_n6 x20_n6 0 1.067930e-16
C20_n7 x20_n7 0 1.067930e-16
C20_n8 x20_n8 0 1.067930e-16
C20_n9 x20_n9 0 1.067930e-16
C20_n10 x20_n10 0 1.067930e-16
C20_n11 x20_n11 0 1.067930e-16
C20_n12 x20_n12 0 1.067930e-16
C20_n13 x20_n13 0 1.067930e-16
C20_n14 x20_n14 0 6.016290e-16
C20_n15 x20_n15 0 9.279160e-16
C20_n16 x20_n16 0 1.067930e-16
C20_n17 x20_n17 0 1.067930e-16
C20_n18 x20_n18 0 1.233470e-16
C20_n19 x20_n19 0 1.629830e-16
C20_n20 x20_n20 0 4.858400e-16
C20_n21 x20_n21 0 1.067930e-16
C20_n22 x20_n22 0 1.067930e-16
C20_n23 x20_n23 0 1.067930e-16
C20_n24 x20_n24 0 1.087780e-16
C20_n25 x20_n25 0 1.570420e-16
C20_n26 x20_n26 0 5.619750e-16
C20_n27 x20_n27 0 1.067930e-16
C20_n28 x20_n28 0 1.067930e-16
C20_n29 x20_n29 0 1.067930e-16
C20_n30 x20_n30 0 1.370770e-16
C20_out x20_out 0 1.980090e-15
* --- RO 21 ---
X21_nand EN x21_n30 0 0 VPWR VPWR x21_n0 sky130_fd_sc_hd__nand2_1
X21_inv1 x21_n0 0 0 VPWR VPWR x21_n1 sky130_fd_sc_hd__inv_1
X21_inv2 x21_n1 0 0 VPWR VPWR x21_n2 sky130_fd_sc_hd__inv_1
X21_inv3 x21_n2 0 0 VPWR VPWR x21_n3 sky130_fd_sc_hd__inv_1
X21_inv4 x21_n3 0 0 VPWR VPWR x21_n4 sky130_fd_sc_hd__inv_1
X21_inv5 x21_n4 0 0 VPWR VPWR x21_n5 sky130_fd_sc_hd__inv_1
X21_inv6 x21_n5 0 0 VPWR VPWR x21_n6 sky130_fd_sc_hd__inv_1
X21_inv7 x21_n6 0 0 VPWR VPWR x21_n7 sky130_fd_sc_hd__inv_1
X21_inv8 x21_n7 0 0 VPWR VPWR x21_n8 sky130_fd_sc_hd__inv_1
X21_inv9 x21_n8 0 0 VPWR VPWR x21_n9 sky130_fd_sc_hd__inv_1
X21_inv10 x21_n9 0 0 VPWR VPWR x21_n10 sky130_fd_sc_hd__inv_1
X21_inv11 x21_n10 0 0 VPWR VPWR x21_n11 sky130_fd_sc_hd__inv_1
X21_inv12 x21_n11 0 0 VPWR VPWR x21_n12 sky130_fd_sc_hd__inv_1
X21_inv13 x21_n12 0 0 VPWR VPWR x21_n13 sky130_fd_sc_hd__inv_1
X21_inv14 x21_n13 0 0 VPWR VPWR x21_n14 sky130_fd_sc_hd__inv_1
X21_inv15 x21_n14 0 0 VPWR VPWR x21_n15 sky130_fd_sc_hd__inv_1
X21_inv16 x21_n15 0 0 VPWR VPWR x21_n16 sky130_fd_sc_hd__inv_1
X21_inv17 x21_n16 0 0 VPWR VPWR x21_n17 sky130_fd_sc_hd__inv_1
X21_inv18 x21_n17 0 0 VPWR VPWR x21_n18 sky130_fd_sc_hd__inv_1
X21_inv19 x21_n18 0 0 VPWR VPWR x21_n19 sky130_fd_sc_hd__inv_1
X21_inv20 x21_n19 0 0 VPWR VPWR x21_n20 sky130_fd_sc_hd__inv_1
X21_inv21 x21_n20 0 0 VPWR VPWR x21_n21 sky130_fd_sc_hd__inv_1
X21_inv22 x21_n21 0 0 VPWR VPWR x21_n22 sky130_fd_sc_hd__inv_1
X21_inv23 x21_n22 0 0 VPWR VPWR x21_n23 sky130_fd_sc_hd__inv_1
X21_inv24 x21_n23 0 0 VPWR VPWR x21_n24 sky130_fd_sc_hd__inv_1
X21_inv25 x21_n24 0 0 VPWR VPWR x21_n25 sky130_fd_sc_hd__inv_1
X21_inv26 x21_n25 0 0 VPWR VPWR x21_n26 sky130_fd_sc_hd__inv_1
X21_inv27 x21_n26 0 0 VPWR VPWR x21_n27 sky130_fd_sc_hd__inv_1
X21_inv28 x21_n27 0 0 VPWR VPWR x21_n28 sky130_fd_sc_hd__inv_1
X21_inv29 x21_n28 0 0 VPWR VPWR x21_n29 sky130_fd_sc_hd__inv_1
X21_inv30 x21_n29 0 0 VPWR VPWR x21_n30 sky130_fd_sc_hd__inv_1
X21_buf x21_n15 0 0 VPWR VPWR x21_out sky130_fd_sc_hd__buf_1
C21_n0 x21_n0 0 1.950380e-16
C21_n1 x21_n1 0 4.604730e-16
C21_n2 x21_n2 0 2.826120e-16
C21_n3 x21_n3 0 6.860680e-16
C21_n4 x21_n4 0 1.889830e-16
C21_n5 x21_n5 0 6.737640e-16
C21_n6 x21_n6 0 2.196860e-16
C21_n7 x21_n7 0 4.916730e-16
C21_n8 x21_n8 0 5.639200e-16
C21_n9 x21_n9 0 1.070610e-16
C21_n10 x21_n10 0 1.160090e-16
C21_n11 x21_n11 0 1.260750e-16
C21_n12 x21_n12 0 1.067930e-16
C21_n13 x21_n13 0 1.556730e-16
C21_n14 x21_n14 0 3.527930e-16
C21_n15 x21_n15 0 4.841900e-16
C21_n16 x21_n16 0 9.534130e-16
C21_n17 x21_n17 0 5.580100e-16
C21_n18 x21_n18 0 4.617230e-16
C21_n19 x21_n19 0 3.142050e-16
C21_n20 x21_n20 0 1.526920e-16
C21_n21 x21_n21 0 4.087240e-16
C21_n22 x21_n22 0 9.455990e-16
C21_n23 x21_n23 0 6.181690e-16
C21_n24 x21_n24 0 2.343880e-16
C21_n25 x21_n25 0 9.026590e-16
C21_n26 x21_n26 0 1.608120e-16
C21_n27 x21_n27 0 2.213250e-16
C21_n28 x21_n28 0 6.402500e-16
C21_n29 x21_n29 0 1.161200e-16
C21_n30 x21_n30 0 1.043350e-16
C21_out x21_out 0 5.350220e-16
* --- RO 22 ---
X22_nand EN x22_n30 0 0 VPWR VPWR x22_n0 sky130_fd_sc_hd__nand2_1
X22_inv1 x22_n0 0 0 VPWR VPWR x22_n1 sky130_fd_sc_hd__inv_1
X22_inv2 x22_n1 0 0 VPWR VPWR x22_n2 sky130_fd_sc_hd__inv_1
X22_inv3 x22_n2 0 0 VPWR VPWR x22_n3 sky130_fd_sc_hd__inv_1
X22_inv4 x22_n3 0 0 VPWR VPWR x22_n4 sky130_fd_sc_hd__inv_1
X22_inv5 x22_n4 0 0 VPWR VPWR x22_n5 sky130_fd_sc_hd__inv_1
X22_inv6 x22_n5 0 0 VPWR VPWR x22_n6 sky130_fd_sc_hd__inv_1
X22_inv7 x22_n6 0 0 VPWR VPWR x22_n7 sky130_fd_sc_hd__inv_1
X22_inv8 x22_n7 0 0 VPWR VPWR x22_n8 sky130_fd_sc_hd__inv_1
X22_inv9 x22_n8 0 0 VPWR VPWR x22_n9 sky130_fd_sc_hd__inv_1
X22_inv10 x22_n9 0 0 VPWR VPWR x22_n10 sky130_fd_sc_hd__inv_1
X22_inv11 x22_n10 0 0 VPWR VPWR x22_n11 sky130_fd_sc_hd__inv_1
X22_inv12 x22_n11 0 0 VPWR VPWR x22_n12 sky130_fd_sc_hd__inv_1
X22_inv13 x22_n12 0 0 VPWR VPWR x22_n13 sky130_fd_sc_hd__inv_1
X22_inv14 x22_n13 0 0 VPWR VPWR x22_n14 sky130_fd_sc_hd__inv_1
X22_inv15 x22_n14 0 0 VPWR VPWR x22_n15 sky130_fd_sc_hd__inv_1
X22_inv16 x22_n15 0 0 VPWR VPWR x22_n16 sky130_fd_sc_hd__inv_1
X22_inv17 x22_n16 0 0 VPWR VPWR x22_n17 sky130_fd_sc_hd__inv_1
X22_inv18 x22_n17 0 0 VPWR VPWR x22_n18 sky130_fd_sc_hd__inv_1
X22_inv19 x22_n18 0 0 VPWR VPWR x22_n19 sky130_fd_sc_hd__inv_1
X22_inv20 x22_n19 0 0 VPWR VPWR x22_n20 sky130_fd_sc_hd__inv_1
X22_inv21 x22_n20 0 0 VPWR VPWR x22_n21 sky130_fd_sc_hd__inv_1
X22_inv22 x22_n21 0 0 VPWR VPWR x22_n22 sky130_fd_sc_hd__inv_1
X22_inv23 x22_n22 0 0 VPWR VPWR x22_n23 sky130_fd_sc_hd__inv_1
X22_inv24 x22_n23 0 0 VPWR VPWR x22_n24 sky130_fd_sc_hd__inv_1
X22_inv25 x22_n24 0 0 VPWR VPWR x22_n25 sky130_fd_sc_hd__inv_1
X22_inv26 x22_n25 0 0 VPWR VPWR x22_n26 sky130_fd_sc_hd__inv_1
X22_inv27 x22_n26 0 0 VPWR VPWR x22_n27 sky130_fd_sc_hd__inv_1
X22_inv28 x22_n27 0 0 VPWR VPWR x22_n28 sky130_fd_sc_hd__inv_1
X22_inv29 x22_n28 0 0 VPWR VPWR x22_n29 sky130_fd_sc_hd__inv_1
X22_inv30 x22_n29 0 0 VPWR VPWR x22_n30 sky130_fd_sc_hd__inv_1
X22_buf x22_n15 0 0 VPWR VPWR x22_out sky130_fd_sc_hd__buf_1
C22_n0 x22_n0 0 2.106590e-16
C22_n1 x22_n1 0 3.353000e-16
C22_n2 x22_n2 0 2.353260e-16
C22_n3 x22_n3 0 1.570420e-16
C22_n4 x22_n4 0 5.619740e-16
C22_n5 x22_n5 0 1.067930e-16
C22_n6 x22_n6 0 1.619220e-16
C22_n7 x22_n7 0 3.959150e-16
C22_n8 x22_n8 0 1.696650e-16
C22_n9 x22_n9 0 5.596070e-16
C22_n10 x22_n10 0 1.547660e-16
C22_n11 x22_n11 0 3.656400e-16
C22_n12 x22_n12 0 9.797350e-16
C22_n13 x22_n13 0 1.230120e-16
C22_n14 x22_n14 0 1.131280e-16
C22_n15 x22_n15 0 1.423910e-15
C22_n16 x22_n16 0 2.045530e-16
C22_n17 x22_n17 0 1.715770e-16
C22_n18 x22_n18 0 6.022800e-16
C22_n19 x22_n19 0 1.709560e-16
C22_n20 x22_n20 0 4.755510e-16
C22_n21 x22_n21 0 4.787840e-16
C22_n22 x22_n22 0 2.396880e-16
C22_n23 x22_n23 0 6.964450e-16
C22_n24 x22_n24 0 6.781810e-16
C22_n25 x22_n25 0 1.574800e-16
C22_n26 x22_n26 0 4.231930e-16
C22_n27 x22_n27 0 1.072090e-16
C22_n28 x22_n28 0 1.263330e-16
C22_n29 x22_n29 0 1.170780e-16
C22_n30 x22_n30 0 3.745080e-16
C22_out x22_out 0 2.173720e-15
* --- RO 23 ---
X23_nand EN x23_n30 0 0 VPWR VPWR x23_n0 sky130_fd_sc_hd__nand2_1
X23_inv1 x23_n0 0 0 VPWR VPWR x23_n1 sky130_fd_sc_hd__inv_1
X23_inv2 x23_n1 0 0 VPWR VPWR x23_n2 sky130_fd_sc_hd__inv_1
X23_inv3 x23_n2 0 0 VPWR VPWR x23_n3 sky130_fd_sc_hd__inv_1
X23_inv4 x23_n3 0 0 VPWR VPWR x23_n4 sky130_fd_sc_hd__inv_1
X23_inv5 x23_n4 0 0 VPWR VPWR x23_n5 sky130_fd_sc_hd__inv_1
X23_inv6 x23_n5 0 0 VPWR VPWR x23_n6 sky130_fd_sc_hd__inv_1
X23_inv7 x23_n6 0 0 VPWR VPWR x23_n7 sky130_fd_sc_hd__inv_1
X23_inv8 x23_n7 0 0 VPWR VPWR x23_n8 sky130_fd_sc_hd__inv_1
X23_inv9 x23_n8 0 0 VPWR VPWR x23_n9 sky130_fd_sc_hd__inv_1
X23_inv10 x23_n9 0 0 VPWR VPWR x23_n10 sky130_fd_sc_hd__inv_1
X23_inv11 x23_n10 0 0 VPWR VPWR x23_n11 sky130_fd_sc_hd__inv_1
X23_inv12 x23_n11 0 0 VPWR VPWR x23_n12 sky130_fd_sc_hd__inv_1
X23_inv13 x23_n12 0 0 VPWR VPWR x23_n13 sky130_fd_sc_hd__inv_1
X23_inv14 x23_n13 0 0 VPWR VPWR x23_n14 sky130_fd_sc_hd__inv_1
X23_inv15 x23_n14 0 0 VPWR VPWR x23_n15 sky130_fd_sc_hd__inv_1
X23_inv16 x23_n15 0 0 VPWR VPWR x23_n16 sky130_fd_sc_hd__inv_1
X23_inv17 x23_n16 0 0 VPWR VPWR x23_n17 sky130_fd_sc_hd__inv_1
X23_inv18 x23_n17 0 0 VPWR VPWR x23_n18 sky130_fd_sc_hd__inv_1
X23_inv19 x23_n18 0 0 VPWR VPWR x23_n19 sky130_fd_sc_hd__inv_1
X23_inv20 x23_n19 0 0 VPWR VPWR x23_n20 sky130_fd_sc_hd__inv_1
X23_inv21 x23_n20 0 0 VPWR VPWR x23_n21 sky130_fd_sc_hd__inv_1
X23_inv22 x23_n21 0 0 VPWR VPWR x23_n22 sky130_fd_sc_hd__inv_1
X23_inv23 x23_n22 0 0 VPWR VPWR x23_n23 sky130_fd_sc_hd__inv_1
X23_inv24 x23_n23 0 0 VPWR VPWR x23_n24 sky130_fd_sc_hd__inv_1
X23_inv25 x23_n24 0 0 VPWR VPWR x23_n25 sky130_fd_sc_hd__inv_1
X23_inv26 x23_n25 0 0 VPWR VPWR x23_n26 sky130_fd_sc_hd__inv_1
X23_inv27 x23_n26 0 0 VPWR VPWR x23_n27 sky130_fd_sc_hd__inv_1
X23_inv28 x23_n27 0 0 VPWR VPWR x23_n28 sky130_fd_sc_hd__inv_1
X23_inv29 x23_n28 0 0 VPWR VPWR x23_n29 sky130_fd_sc_hd__inv_1
X23_inv30 x23_n29 0 0 VPWR VPWR x23_n30 sky130_fd_sc_hd__inv_1
X23_buf x23_n15 0 0 VPWR VPWR x23_out sky130_fd_sc_hd__buf_1
C23_n0 x23_n0 0 2.344110e-16
C23_n1 x23_n1 0 3.259990e-16
C23_n2 x23_n2 0 2.504440e-16
C23_n3 x23_n3 0 1.628300e-16
C23_n4 x23_n4 0 1.628300e-16
C23_n5 x23_n5 0 1.628300e-16
C23_n6 x23_n6 0 2.373590e-16
C23_n7 x23_n7 0 1.628300e-16
C23_n8 x23_n8 0 1.628300e-16
C23_n9 x23_n9 0 1.628300e-16
C23_n10 x23_n10 0 4.988070e-16
C23_n11 x23_n11 0 2.789780e-16
C23_n12 x23_n12 0 5.359710e-16
C23_n13 x23_n13 0 8.421950e-16
C23_n14 x23_n14 0 1.629830e-16
C23_n15 x23_n15 0 8.043250e-16
C23_n16 x23_n16 0 1.250960e-16
C23_n17 x23_n17 0 1.250960e-16
C23_n18 x23_n18 0 1.250960e-16
C23_n19 x23_n19 0 1.250960e-16
C23_n20 x23_n20 0 1.250960e-16
C23_n21 x23_n21 0 1.895980e-16
C23_n22 x23_n22 0 5.511720e-16
C23_n23 x23_n23 0 7.346270e-16
C23_n24 x23_n24 0 1.696650e-16
C23_n25 x23_n25 0 7.299110e-16
C23_n26 x23_n26 0 1.250960e-16
C23_n27 x23_n27 0 4.251230e-16
C23_n28 x23_n28 0 6.275420e-16
C23_n29 x23_n29 0 6.947720e-16
C23_n30 x23_n30 0 6.440570e-16
C23_out x23_out 0 4.713130e-16
* --- RO 24 ---
X24_nand EN x24_n30 0 0 VPWR VPWR x24_n0 sky130_fd_sc_hd__nand2_1
X24_inv1 x24_n0 0 0 VPWR VPWR x24_n1 sky130_fd_sc_hd__inv_1
X24_inv2 x24_n1 0 0 VPWR VPWR x24_n2 sky130_fd_sc_hd__inv_1
X24_inv3 x24_n2 0 0 VPWR VPWR x24_n3 sky130_fd_sc_hd__inv_1
X24_inv4 x24_n3 0 0 VPWR VPWR x24_n4 sky130_fd_sc_hd__inv_1
X24_inv5 x24_n4 0 0 VPWR VPWR x24_n5 sky130_fd_sc_hd__inv_1
X24_inv6 x24_n5 0 0 VPWR VPWR x24_n6 sky130_fd_sc_hd__inv_1
X24_inv7 x24_n6 0 0 VPWR VPWR x24_n7 sky130_fd_sc_hd__inv_1
X24_inv8 x24_n7 0 0 VPWR VPWR x24_n8 sky130_fd_sc_hd__inv_1
X24_inv9 x24_n8 0 0 VPWR VPWR x24_n9 sky130_fd_sc_hd__inv_1
X24_inv10 x24_n9 0 0 VPWR VPWR x24_n10 sky130_fd_sc_hd__inv_1
X24_inv11 x24_n10 0 0 VPWR VPWR x24_n11 sky130_fd_sc_hd__inv_1
X24_inv12 x24_n11 0 0 VPWR VPWR x24_n12 sky130_fd_sc_hd__inv_1
X24_inv13 x24_n12 0 0 VPWR VPWR x24_n13 sky130_fd_sc_hd__inv_1
X24_inv14 x24_n13 0 0 VPWR VPWR x24_n14 sky130_fd_sc_hd__inv_1
X24_inv15 x24_n14 0 0 VPWR VPWR x24_n15 sky130_fd_sc_hd__inv_1
X24_inv16 x24_n15 0 0 VPWR VPWR x24_n16 sky130_fd_sc_hd__inv_1
X24_inv17 x24_n16 0 0 VPWR VPWR x24_n17 sky130_fd_sc_hd__inv_1
X24_inv18 x24_n17 0 0 VPWR VPWR x24_n18 sky130_fd_sc_hd__inv_1
X24_inv19 x24_n18 0 0 VPWR VPWR x24_n19 sky130_fd_sc_hd__inv_1
X24_inv20 x24_n19 0 0 VPWR VPWR x24_n20 sky130_fd_sc_hd__inv_1
X24_inv21 x24_n20 0 0 VPWR VPWR x24_n21 sky130_fd_sc_hd__inv_1
X24_inv22 x24_n21 0 0 VPWR VPWR x24_n22 sky130_fd_sc_hd__inv_1
X24_inv23 x24_n22 0 0 VPWR VPWR x24_n23 sky130_fd_sc_hd__inv_1
X24_inv24 x24_n23 0 0 VPWR VPWR x24_n24 sky130_fd_sc_hd__inv_1
X24_inv25 x24_n24 0 0 VPWR VPWR x24_n25 sky130_fd_sc_hd__inv_1
X24_inv26 x24_n25 0 0 VPWR VPWR x24_n26 sky130_fd_sc_hd__inv_1
X24_inv27 x24_n26 0 0 VPWR VPWR x24_n27 sky130_fd_sc_hd__inv_1
X24_inv28 x24_n27 0 0 VPWR VPWR x24_n28 sky130_fd_sc_hd__inv_1
X24_inv29 x24_n28 0 0 VPWR VPWR x24_n29 sky130_fd_sc_hd__inv_1
X24_inv30 x24_n29 0 0 VPWR VPWR x24_n30 sky130_fd_sc_hd__inv_1
X24_buf x24_n15 0 0 VPWR VPWR x24_out sky130_fd_sc_hd__buf_1
C24_n0 x24_n0 0 7.176510e-16
C24_n1 x24_n1 0 6.111050e-16
C24_n2 x24_n2 0 4.629280e-16
C24_n3 x24_n3 0 1.067930e-16
C24_n4 x24_n4 0 1.067930e-16
C24_n5 x24_n5 0 1.067930e-16
C24_n6 x24_n6 0 1.608010e-16
C24_n7 x24_n7 0 3.630980e-16
C24_n8 x24_n8 0 3.198170e-16
C24_n9 x24_n9 0 1.628300e-16
C24_n10 x24_n10 0 1.628300e-16
C24_n11 x24_n11 0 2.297490e-16
C24_n12 x24_n12 0 6.214140e-16
C24_n13 x24_n13 0 1.251130e-16
C24_n14 x24_n14 0 1.263090e-16
C24_n15 x24_n15 0 1.446580e-15
C24_n16 x24_n16 0 8.011690e-16
C24_n17 x24_n17 0 1.565630e-16
C24_n18 x24_n18 0 1.564940e-16
C24_n19 x24_n19 0 4.647970e-16
C24_n20 x24_n20 0 3.813150e-16
C24_n21 x24_n21 0 5.364940e-16
C24_n22 x24_n22 0 1.547660e-16
C24_n23 x24_n23 0 5.176140e-16
C24_n24 x24_n24 0 1.743900e-16
C24_n25 x24_n25 0 1.628300e-16
C24_n26 x24_n26 0 2.292580e-16
C24_n27 x24_n27 0 6.037320e-16
C24_n28 x24_n28 0 1.250960e-16
C24_n29 x24_n29 0 1.250960e-16
C24_n30 x24_n30 0 1.376050e-16
C24_out x24_out 0 6.986840e-16
* --- RO 25 ---
X25_nand EN x25_n30 0 0 VPWR VPWR x25_n0 sky130_fd_sc_hd__nand2_1
X25_inv1 x25_n0 0 0 VPWR VPWR x25_n1 sky130_fd_sc_hd__inv_1
X25_inv2 x25_n1 0 0 VPWR VPWR x25_n2 sky130_fd_sc_hd__inv_1
X25_inv3 x25_n2 0 0 VPWR VPWR x25_n3 sky130_fd_sc_hd__inv_1
X25_inv4 x25_n3 0 0 VPWR VPWR x25_n4 sky130_fd_sc_hd__inv_1
X25_inv5 x25_n4 0 0 VPWR VPWR x25_n5 sky130_fd_sc_hd__inv_1
X25_inv6 x25_n5 0 0 VPWR VPWR x25_n6 sky130_fd_sc_hd__inv_1
X25_inv7 x25_n6 0 0 VPWR VPWR x25_n7 sky130_fd_sc_hd__inv_1
X25_inv8 x25_n7 0 0 VPWR VPWR x25_n8 sky130_fd_sc_hd__inv_1
X25_inv9 x25_n8 0 0 VPWR VPWR x25_n9 sky130_fd_sc_hd__inv_1
X25_inv10 x25_n9 0 0 VPWR VPWR x25_n10 sky130_fd_sc_hd__inv_1
X25_inv11 x25_n10 0 0 VPWR VPWR x25_n11 sky130_fd_sc_hd__inv_1
X25_inv12 x25_n11 0 0 VPWR VPWR x25_n12 sky130_fd_sc_hd__inv_1
X25_inv13 x25_n12 0 0 VPWR VPWR x25_n13 sky130_fd_sc_hd__inv_1
X25_inv14 x25_n13 0 0 VPWR VPWR x25_n14 sky130_fd_sc_hd__inv_1
X25_inv15 x25_n14 0 0 VPWR VPWR x25_n15 sky130_fd_sc_hd__inv_1
X25_inv16 x25_n15 0 0 VPWR VPWR x25_n16 sky130_fd_sc_hd__inv_1
X25_inv17 x25_n16 0 0 VPWR VPWR x25_n17 sky130_fd_sc_hd__inv_1
X25_inv18 x25_n17 0 0 VPWR VPWR x25_n18 sky130_fd_sc_hd__inv_1
X25_inv19 x25_n18 0 0 VPWR VPWR x25_n19 sky130_fd_sc_hd__inv_1
X25_inv20 x25_n19 0 0 VPWR VPWR x25_n20 sky130_fd_sc_hd__inv_1
X25_inv21 x25_n20 0 0 VPWR VPWR x25_n21 sky130_fd_sc_hd__inv_1
X25_inv22 x25_n21 0 0 VPWR VPWR x25_n22 sky130_fd_sc_hd__inv_1
X25_inv23 x25_n22 0 0 VPWR VPWR x25_n23 sky130_fd_sc_hd__inv_1
X25_inv24 x25_n23 0 0 VPWR VPWR x25_n24 sky130_fd_sc_hd__inv_1
X25_inv25 x25_n24 0 0 VPWR VPWR x25_n25 sky130_fd_sc_hd__inv_1
X25_inv26 x25_n25 0 0 VPWR VPWR x25_n26 sky130_fd_sc_hd__inv_1
X25_inv27 x25_n26 0 0 VPWR VPWR x25_n27 sky130_fd_sc_hd__inv_1
X25_inv28 x25_n27 0 0 VPWR VPWR x25_n28 sky130_fd_sc_hd__inv_1
X25_inv29 x25_n28 0 0 VPWR VPWR x25_n29 sky130_fd_sc_hd__inv_1
X25_inv30 x25_n29 0 0 VPWR VPWR x25_n30 sky130_fd_sc_hd__inv_1
X25_buf x25_n15 0 0 VPWR VPWR x25_out sky130_fd_sc_hd__buf_1
C25_n0 x25_n0 0 2.245420e-16
C25_n1 x25_n1 0 3.728150e-16
C25_n2 x25_n2 0 1.170330e-16
C25_n3 x25_n3 0 4.231620e-16
C25_n4 x25_n4 0 1.231780e-16
C25_n5 x25_n5 0 1.629830e-16
C25_n6 x25_n6 0 6.265760e-16
C25_n7 x25_n7 0 1.069210e-16
C25_n8 x25_n8 0 1.070650e-16
C25_n9 x25_n9 0 1.399570e-16
C25_n10 x25_n10 0 1.249530e-16
C25_n11 x25_n11 0 1.868600e-16
C25_n12 x25_n12 0 4.330820e-16
C25_n13 x25_n13 0 6.820780e-16
C25_n14 x25_n14 0 1.093170e-16
C25_n15 x25_n15 0 5.805450e-16
C25_n16 x25_n16 0 5.212750e-16
C25_n17 x25_n17 0 1.067930e-16
C25_n18 x25_n18 0 8.320630e-16
C25_n19 x25_n19 0 5.806500e-16
C25_n20 x25_n20 0 5.293630e-16
C25_n21 x25_n21 0 2.516050e-16
C25_n22 x25_n22 0 4.366130e-16
C25_n23 x25_n23 0 6.729060e-16
C25_n24 x25_n24 0 5.396180e-16
C25_n25 x25_n25 0 1.201340e-16
C25_n26 x25_n26 0 1.067930e-16
C25_n27 x25_n27 0 1.073340e-16
C25_n28 x25_n28 0 1.747160e-16
C25_n29 x25_n29 0 1.073340e-16
C25_n30 x25_n30 0 7.090560e-16
C25_out x25_out 0 1.613660e-16
* --- RO 26 ---
X26_nand EN x26_n30 0 0 VPWR VPWR x26_n0 sky130_fd_sc_hd__nand2_1
X26_inv1 x26_n0 0 0 VPWR VPWR x26_n1 sky130_fd_sc_hd__inv_1
X26_inv2 x26_n1 0 0 VPWR VPWR x26_n2 sky130_fd_sc_hd__inv_1
X26_inv3 x26_n2 0 0 VPWR VPWR x26_n3 sky130_fd_sc_hd__inv_1
X26_inv4 x26_n3 0 0 VPWR VPWR x26_n4 sky130_fd_sc_hd__inv_1
X26_inv5 x26_n4 0 0 VPWR VPWR x26_n5 sky130_fd_sc_hd__inv_1
X26_inv6 x26_n5 0 0 VPWR VPWR x26_n6 sky130_fd_sc_hd__inv_1
X26_inv7 x26_n6 0 0 VPWR VPWR x26_n7 sky130_fd_sc_hd__inv_1
X26_inv8 x26_n7 0 0 VPWR VPWR x26_n8 sky130_fd_sc_hd__inv_1
X26_inv9 x26_n8 0 0 VPWR VPWR x26_n9 sky130_fd_sc_hd__inv_1
X26_inv10 x26_n9 0 0 VPWR VPWR x26_n10 sky130_fd_sc_hd__inv_1
X26_inv11 x26_n10 0 0 VPWR VPWR x26_n11 sky130_fd_sc_hd__inv_1
X26_inv12 x26_n11 0 0 VPWR VPWR x26_n12 sky130_fd_sc_hd__inv_1
X26_inv13 x26_n12 0 0 VPWR VPWR x26_n13 sky130_fd_sc_hd__inv_1
X26_inv14 x26_n13 0 0 VPWR VPWR x26_n14 sky130_fd_sc_hd__inv_1
X26_inv15 x26_n14 0 0 VPWR VPWR x26_n15 sky130_fd_sc_hd__inv_1
X26_inv16 x26_n15 0 0 VPWR VPWR x26_n16 sky130_fd_sc_hd__inv_1
X26_inv17 x26_n16 0 0 VPWR VPWR x26_n17 sky130_fd_sc_hd__inv_1
X26_inv18 x26_n17 0 0 VPWR VPWR x26_n18 sky130_fd_sc_hd__inv_1
X26_inv19 x26_n18 0 0 VPWR VPWR x26_n19 sky130_fd_sc_hd__inv_1
X26_inv20 x26_n19 0 0 VPWR VPWR x26_n20 sky130_fd_sc_hd__inv_1
X26_inv21 x26_n20 0 0 VPWR VPWR x26_n21 sky130_fd_sc_hd__inv_1
X26_inv22 x26_n21 0 0 VPWR VPWR x26_n22 sky130_fd_sc_hd__inv_1
X26_inv23 x26_n22 0 0 VPWR VPWR x26_n23 sky130_fd_sc_hd__inv_1
X26_inv24 x26_n23 0 0 VPWR VPWR x26_n24 sky130_fd_sc_hd__inv_1
X26_inv25 x26_n24 0 0 VPWR VPWR x26_n25 sky130_fd_sc_hd__inv_1
X26_inv26 x26_n25 0 0 VPWR VPWR x26_n26 sky130_fd_sc_hd__inv_1
X26_inv27 x26_n26 0 0 VPWR VPWR x26_n27 sky130_fd_sc_hd__inv_1
X26_inv28 x26_n27 0 0 VPWR VPWR x26_n28 sky130_fd_sc_hd__inv_1
X26_inv29 x26_n28 0 0 VPWR VPWR x26_n29 sky130_fd_sc_hd__inv_1
X26_inv30 x26_n29 0 0 VPWR VPWR x26_n30 sky130_fd_sc_hd__inv_1
X26_buf x26_n15 0 0 VPWR VPWR x26_out sky130_fd_sc_hd__buf_1
C26_n0 x26_n0 0 3.298270e-16
C26_n1 x26_n1 0 6.657330e-16
C26_n2 x26_n2 0 1.710930e-16
C26_n3 x26_n3 0 4.593540e-16
C26_n4 x26_n4 0 5.758290e-16
C26_n5 x26_n5 0 1.805790e-16
C26_n6 x26_n6 0 5.313300e-16
C26_n7 x26_n7 0 3.609680e-16
C26_n8 x26_n8 0 1.632240e-16
C26_n9 x26_n9 0 4.856240e-16
C26_n10 x26_n10 0 1.709010e-16
C26_n11 x26_n11 0 5.384430e-16
C26_n12 x26_n12 0 1.725430e-16
C26_n13 x26_n13 0 8.584690e-16
C26_n14 x26_n14 0 1.414740e-16
C26_n15 x26_n15 0 4.474630e-15
C26_n16 x26_n16 0 1.082780e-16
C26_n17 x26_n17 0 4.122620e-16
C26_n18 x26_n18 0 1.250960e-16
C26_n19 x26_n19 0 1.696650e-16
C26_n20 x26_n20 0 7.242120e-16
C26_n21 x26_n21 0 6.209250e-16
C26_n22 x26_n22 0 5.494410e-16
C26_n23 x26_n23 0 2.125310e-16
C26_n24 x26_n24 0 5.910270e-16
C26_n25 x26_n25 0 1.067930e-16
C26_n26 x26_n26 0 1.067930e-16
C26_n27 x26_n27 0 1.067930e-16
C26_n28 x26_n28 0 4.362080e-16
C26_n29 x26_n29 0 1.568820e-16
C26_n30 x26_n30 0 3.623590e-16
C26_out x26_out 0 3.717900e-16
* --- RO 27 ---
X27_nand EN x27_n30 0 0 VPWR VPWR x27_n0 sky130_fd_sc_hd__nand2_1
X27_inv1 x27_n0 0 0 VPWR VPWR x27_n1 sky130_fd_sc_hd__inv_1
X27_inv2 x27_n1 0 0 VPWR VPWR x27_n2 sky130_fd_sc_hd__inv_1
X27_inv3 x27_n2 0 0 VPWR VPWR x27_n3 sky130_fd_sc_hd__inv_1
X27_inv4 x27_n3 0 0 VPWR VPWR x27_n4 sky130_fd_sc_hd__inv_1
X27_inv5 x27_n4 0 0 VPWR VPWR x27_n5 sky130_fd_sc_hd__inv_1
X27_inv6 x27_n5 0 0 VPWR VPWR x27_n6 sky130_fd_sc_hd__inv_1
X27_inv7 x27_n6 0 0 VPWR VPWR x27_n7 sky130_fd_sc_hd__inv_1
X27_inv8 x27_n7 0 0 VPWR VPWR x27_n8 sky130_fd_sc_hd__inv_1
X27_inv9 x27_n8 0 0 VPWR VPWR x27_n9 sky130_fd_sc_hd__inv_1
X27_inv10 x27_n9 0 0 VPWR VPWR x27_n10 sky130_fd_sc_hd__inv_1
X27_inv11 x27_n10 0 0 VPWR VPWR x27_n11 sky130_fd_sc_hd__inv_1
X27_inv12 x27_n11 0 0 VPWR VPWR x27_n12 sky130_fd_sc_hd__inv_1
X27_inv13 x27_n12 0 0 VPWR VPWR x27_n13 sky130_fd_sc_hd__inv_1
X27_inv14 x27_n13 0 0 VPWR VPWR x27_n14 sky130_fd_sc_hd__inv_1
X27_inv15 x27_n14 0 0 VPWR VPWR x27_n15 sky130_fd_sc_hd__inv_1
X27_inv16 x27_n15 0 0 VPWR VPWR x27_n16 sky130_fd_sc_hd__inv_1
X27_inv17 x27_n16 0 0 VPWR VPWR x27_n17 sky130_fd_sc_hd__inv_1
X27_inv18 x27_n17 0 0 VPWR VPWR x27_n18 sky130_fd_sc_hd__inv_1
X27_inv19 x27_n18 0 0 VPWR VPWR x27_n19 sky130_fd_sc_hd__inv_1
X27_inv20 x27_n19 0 0 VPWR VPWR x27_n20 sky130_fd_sc_hd__inv_1
X27_inv21 x27_n20 0 0 VPWR VPWR x27_n21 sky130_fd_sc_hd__inv_1
X27_inv22 x27_n21 0 0 VPWR VPWR x27_n22 sky130_fd_sc_hd__inv_1
X27_inv23 x27_n22 0 0 VPWR VPWR x27_n23 sky130_fd_sc_hd__inv_1
X27_inv24 x27_n23 0 0 VPWR VPWR x27_n24 sky130_fd_sc_hd__inv_1
X27_inv25 x27_n24 0 0 VPWR VPWR x27_n25 sky130_fd_sc_hd__inv_1
X27_inv26 x27_n25 0 0 VPWR VPWR x27_n26 sky130_fd_sc_hd__inv_1
X27_inv27 x27_n26 0 0 VPWR VPWR x27_n27 sky130_fd_sc_hd__inv_1
X27_inv28 x27_n27 0 0 VPWR VPWR x27_n28 sky130_fd_sc_hd__inv_1
X27_inv29 x27_n28 0 0 VPWR VPWR x27_n29 sky130_fd_sc_hd__inv_1
X27_inv30 x27_n29 0 0 VPWR VPWR x27_n30 sky130_fd_sc_hd__inv_1
X27_buf x27_n15 0 0 VPWR VPWR x27_out sky130_fd_sc_hd__buf_1
C27_n0 x27_n0 0 7.625200e-16
C27_n1 x27_n1 0 3.109720e-16
C27_n2 x27_n2 0 2.502930e-16
C27_n3 x27_n3 0 5.640540e-16
C27_n4 x27_n4 0 4.209770e-16
C27_n5 x27_n5 0 6.656110e-16
C27_n6 x27_n6 0 5.935760e-16
C27_n7 x27_n7 0 1.628300e-16
C27_n8 x27_n8 0 6.091990e-16
C27_n9 x27_n9 0 2.992350e-16
C27_n10 x27_n10 0 6.247630e-16
C27_n11 x27_n11 0 2.408200e-16
C27_n12 x27_n12 0 3.184090e-16
C27_n13 x27_n13 0 1.582210e-16
C27_n14 x27_n14 0 5.179970e-16
C27_n15 x27_n15 0 5.616850e-16
C27_n16 x27_n16 0 1.067930e-16
C27_n17 x27_n17 0 1.067930e-16
C27_n18 x27_n18 0 1.067930e-16
C27_n19 x27_n19 0 1.067930e-16
C27_n20 x27_n20 0 1.067930e-16
C27_n21 x27_n21 0 1.231760e-16
C27_n22 x27_n22 0 1.629830e-16
C27_n23 x27_n23 0 6.267370e-16
C27_n24 x27_n24 0 1.131280e-16
C27_n25 x27_n25 0 1.136000e-16
C27_n26 x27_n26 0 5.988870e-16
C27_n27 x27_n27 0 1.678540e-16
C27_n28 x27_n28 0 5.902000e-16
C27_n29 x27_n29 0 3.176260e-16
C27_n30 x27_n30 0 8.259530e-16
C27_out x27_out 0 6.154130e-16
* --- RO 28 ---
X28_nand EN x28_n30 0 0 VPWR VPWR x28_n0 sky130_fd_sc_hd__nand2_1
X28_inv1 x28_n0 0 0 VPWR VPWR x28_n1 sky130_fd_sc_hd__inv_1
X28_inv2 x28_n1 0 0 VPWR VPWR x28_n2 sky130_fd_sc_hd__inv_1
X28_inv3 x28_n2 0 0 VPWR VPWR x28_n3 sky130_fd_sc_hd__inv_1
X28_inv4 x28_n3 0 0 VPWR VPWR x28_n4 sky130_fd_sc_hd__inv_1
X28_inv5 x28_n4 0 0 VPWR VPWR x28_n5 sky130_fd_sc_hd__inv_1
X28_inv6 x28_n5 0 0 VPWR VPWR x28_n6 sky130_fd_sc_hd__inv_1
X28_inv7 x28_n6 0 0 VPWR VPWR x28_n7 sky130_fd_sc_hd__inv_1
X28_inv8 x28_n7 0 0 VPWR VPWR x28_n8 sky130_fd_sc_hd__inv_1
X28_inv9 x28_n8 0 0 VPWR VPWR x28_n9 sky130_fd_sc_hd__inv_1
X28_inv10 x28_n9 0 0 VPWR VPWR x28_n10 sky130_fd_sc_hd__inv_1
X28_inv11 x28_n10 0 0 VPWR VPWR x28_n11 sky130_fd_sc_hd__inv_1
X28_inv12 x28_n11 0 0 VPWR VPWR x28_n12 sky130_fd_sc_hd__inv_1
X28_inv13 x28_n12 0 0 VPWR VPWR x28_n13 sky130_fd_sc_hd__inv_1
X28_inv14 x28_n13 0 0 VPWR VPWR x28_n14 sky130_fd_sc_hd__inv_1
X28_inv15 x28_n14 0 0 VPWR VPWR x28_n15 sky130_fd_sc_hd__inv_1
X28_inv16 x28_n15 0 0 VPWR VPWR x28_n16 sky130_fd_sc_hd__inv_1
X28_inv17 x28_n16 0 0 VPWR VPWR x28_n17 sky130_fd_sc_hd__inv_1
X28_inv18 x28_n17 0 0 VPWR VPWR x28_n18 sky130_fd_sc_hd__inv_1
X28_inv19 x28_n18 0 0 VPWR VPWR x28_n19 sky130_fd_sc_hd__inv_1
X28_inv20 x28_n19 0 0 VPWR VPWR x28_n20 sky130_fd_sc_hd__inv_1
X28_inv21 x28_n20 0 0 VPWR VPWR x28_n21 sky130_fd_sc_hd__inv_1
X28_inv22 x28_n21 0 0 VPWR VPWR x28_n22 sky130_fd_sc_hd__inv_1
X28_inv23 x28_n22 0 0 VPWR VPWR x28_n23 sky130_fd_sc_hd__inv_1
X28_inv24 x28_n23 0 0 VPWR VPWR x28_n24 sky130_fd_sc_hd__inv_1
X28_inv25 x28_n24 0 0 VPWR VPWR x28_n25 sky130_fd_sc_hd__inv_1
X28_inv26 x28_n25 0 0 VPWR VPWR x28_n26 sky130_fd_sc_hd__inv_1
X28_inv27 x28_n26 0 0 VPWR VPWR x28_n27 sky130_fd_sc_hd__inv_1
X28_inv28 x28_n27 0 0 VPWR VPWR x28_n28 sky130_fd_sc_hd__inv_1
X28_inv29 x28_n28 0 0 VPWR VPWR x28_n29 sky130_fd_sc_hd__inv_1
X28_inv30 x28_n29 0 0 VPWR VPWR x28_n30 sky130_fd_sc_hd__inv_1
X28_buf x28_n15 0 0 VPWR VPWR x28_out sky130_fd_sc_hd__buf_1
C28_n0 x28_n0 0 2.058570e-16
C28_n1 x28_n1 0 1.637040e-16
C28_n2 x28_n2 0 4.582550e-16
C28_n3 x28_n3 0 2.380330e-16
C28_n4 x28_n4 0 5.043240e-16
C28_n5 x28_n5 0 8.009110e-16
C28_n6 x28_n6 0 3.971370e-16
C28_n7 x28_n7 0 1.067930e-16
C28_n8 x28_n8 0 1.067930e-16
C28_n9 x28_n9 0 1.067930e-16
C28_n10 x28_n10 0 2.606020e-16
C28_n11 x28_n11 0 6.660400e-16
C28_n12 x28_n12 0 1.628300e-16
C28_n13 x28_n13 0 5.729470e-16
C28_n14 x28_n14 0 2.125310e-16
C28_n15 x28_n15 0 6.911410e-16
C28_n16 x28_n16 0 1.556730e-16
C28_n17 x28_n17 0 1.556730e-16
C28_n18 x28_n18 0 3.873270e-16
C28_n19 x28_n19 0 1.067930e-16
C28_n20 x28_n20 0 3.087400e-16
C28_n21 x28_n21 0 1.067930e-16
C28_n22 x28_n22 0 1.070450e-16
C28_n23 x28_n23 0 1.640130e-16
C28_n24 x28_n24 0 6.685570e-16
C28_n25 x28_n25 0 2.505100e-16
C28_n26 x28_n26 0 4.794880e-16
C28_n27 x28_n27 0 5.831650e-16
C28_n28 x28_n28 0 1.067930e-16
C28_n29 x28_n29 0 1.619200e-16
C28_n30 x28_n30 0 3.837890e-16
C28_out x28_out 0 8.848340e-16
* --- RO 29 ---
X29_nand EN x29_n30 0 0 VPWR VPWR x29_n0 sky130_fd_sc_hd__nand2_1
X29_inv1 x29_n0 0 0 VPWR VPWR x29_n1 sky130_fd_sc_hd__inv_1
X29_inv2 x29_n1 0 0 VPWR VPWR x29_n2 sky130_fd_sc_hd__inv_1
X29_inv3 x29_n2 0 0 VPWR VPWR x29_n3 sky130_fd_sc_hd__inv_1
X29_inv4 x29_n3 0 0 VPWR VPWR x29_n4 sky130_fd_sc_hd__inv_1
X29_inv5 x29_n4 0 0 VPWR VPWR x29_n5 sky130_fd_sc_hd__inv_1
X29_inv6 x29_n5 0 0 VPWR VPWR x29_n6 sky130_fd_sc_hd__inv_1
X29_inv7 x29_n6 0 0 VPWR VPWR x29_n7 sky130_fd_sc_hd__inv_1
X29_inv8 x29_n7 0 0 VPWR VPWR x29_n8 sky130_fd_sc_hd__inv_1
X29_inv9 x29_n8 0 0 VPWR VPWR x29_n9 sky130_fd_sc_hd__inv_1
X29_inv10 x29_n9 0 0 VPWR VPWR x29_n10 sky130_fd_sc_hd__inv_1
X29_inv11 x29_n10 0 0 VPWR VPWR x29_n11 sky130_fd_sc_hd__inv_1
X29_inv12 x29_n11 0 0 VPWR VPWR x29_n12 sky130_fd_sc_hd__inv_1
X29_inv13 x29_n12 0 0 VPWR VPWR x29_n13 sky130_fd_sc_hd__inv_1
X29_inv14 x29_n13 0 0 VPWR VPWR x29_n14 sky130_fd_sc_hd__inv_1
X29_inv15 x29_n14 0 0 VPWR VPWR x29_n15 sky130_fd_sc_hd__inv_1
X29_inv16 x29_n15 0 0 VPWR VPWR x29_n16 sky130_fd_sc_hd__inv_1
X29_inv17 x29_n16 0 0 VPWR VPWR x29_n17 sky130_fd_sc_hd__inv_1
X29_inv18 x29_n17 0 0 VPWR VPWR x29_n18 sky130_fd_sc_hd__inv_1
X29_inv19 x29_n18 0 0 VPWR VPWR x29_n19 sky130_fd_sc_hd__inv_1
X29_inv20 x29_n19 0 0 VPWR VPWR x29_n20 sky130_fd_sc_hd__inv_1
X29_inv21 x29_n20 0 0 VPWR VPWR x29_n21 sky130_fd_sc_hd__inv_1
X29_inv22 x29_n21 0 0 VPWR VPWR x29_n22 sky130_fd_sc_hd__inv_1
X29_inv23 x29_n22 0 0 VPWR VPWR x29_n23 sky130_fd_sc_hd__inv_1
X29_inv24 x29_n23 0 0 VPWR VPWR x29_n24 sky130_fd_sc_hd__inv_1
X29_inv25 x29_n24 0 0 VPWR VPWR x29_n25 sky130_fd_sc_hd__inv_1
X29_inv26 x29_n25 0 0 VPWR VPWR x29_n26 sky130_fd_sc_hd__inv_1
X29_inv27 x29_n26 0 0 VPWR VPWR x29_n27 sky130_fd_sc_hd__inv_1
X29_inv28 x29_n27 0 0 VPWR VPWR x29_n28 sky130_fd_sc_hd__inv_1
X29_inv29 x29_n28 0 0 VPWR VPWR x29_n29 sky130_fd_sc_hd__inv_1
X29_inv30 x29_n29 0 0 VPWR VPWR x29_n30 sky130_fd_sc_hd__inv_1
X29_buf x29_n15 0 0 VPWR VPWR x29_out sky130_fd_sc_hd__buf_1
C29_n0 x29_n0 0 8.831220e-16
C29_n1 x29_n1 0 1.646100e-16
C29_n2 x29_n2 0 1.556730e-16
C29_n3 x29_n3 0 2.534330e-16
C29_n4 x29_n4 0 1.613470e-16
C29_n5 x29_n5 0 7.506740e-16
C29_n6 x29_n6 0 2.203370e-16
C29_n7 x29_n7 0 5.571100e-16
C29_n8 x29_n8 0 1.637010e-16
C29_n9 x29_n9 0 4.365540e-16
C29_n10 x29_n10 0 2.744100e-16
C29_n11 x29_n11 0 5.938030e-16
C29_n12 x29_n12 0 4.382420e-16
C29_n13 x29_n13 0 1.067930e-16
C29_n14 x29_n14 0 1.067930e-16
C29_n15 x29_n15 0 1.058640e-15
C29_n16 x29_n16 0 5.771590e-16
C29_n17 x29_n17 0 1.824150e-16
C29_n18 x29_n18 0 7.520760e-16
C29_n19 x29_n19 0 7.413790e-16
C29_n20 x29_n20 0 1.574940e-16
C29_n21 x29_n21 0 2.231730e-16
C29_n22 x29_n22 0 3.362630e-16
C29_n23 x29_n23 0 3.902490e-16
C29_n24 x29_n24 0 7.461150e-16
C29_n25 x29_n25 0 7.930550e-16
C29_n26 x29_n26 0 5.293450e-16
C29_n27 x29_n27 0 5.057400e-16
C29_n28 x29_n28 0 2.310270e-16
C29_n29 x29_n29 0 5.984420e-16
C29_n30 x29_n30 0 5.305990e-16
C29_out x29_out 0 6.050310e-16
* --- RO 30 ---
X30_nand EN x30_n30 0 0 VPWR VPWR x30_n0 sky130_fd_sc_hd__nand2_1
X30_inv1 x30_n0 0 0 VPWR VPWR x30_n1 sky130_fd_sc_hd__inv_1
X30_inv2 x30_n1 0 0 VPWR VPWR x30_n2 sky130_fd_sc_hd__inv_1
X30_inv3 x30_n2 0 0 VPWR VPWR x30_n3 sky130_fd_sc_hd__inv_1
X30_inv4 x30_n3 0 0 VPWR VPWR x30_n4 sky130_fd_sc_hd__inv_1
X30_inv5 x30_n4 0 0 VPWR VPWR x30_n5 sky130_fd_sc_hd__inv_1
X30_inv6 x30_n5 0 0 VPWR VPWR x30_n6 sky130_fd_sc_hd__inv_1
X30_inv7 x30_n6 0 0 VPWR VPWR x30_n7 sky130_fd_sc_hd__inv_1
X30_inv8 x30_n7 0 0 VPWR VPWR x30_n8 sky130_fd_sc_hd__inv_1
X30_inv9 x30_n8 0 0 VPWR VPWR x30_n9 sky130_fd_sc_hd__inv_1
X30_inv10 x30_n9 0 0 VPWR VPWR x30_n10 sky130_fd_sc_hd__inv_1
X30_inv11 x30_n10 0 0 VPWR VPWR x30_n11 sky130_fd_sc_hd__inv_1
X30_inv12 x30_n11 0 0 VPWR VPWR x30_n12 sky130_fd_sc_hd__inv_1
X30_inv13 x30_n12 0 0 VPWR VPWR x30_n13 sky130_fd_sc_hd__inv_1
X30_inv14 x30_n13 0 0 VPWR VPWR x30_n14 sky130_fd_sc_hd__inv_1
X30_inv15 x30_n14 0 0 VPWR VPWR x30_n15 sky130_fd_sc_hd__inv_1
X30_inv16 x30_n15 0 0 VPWR VPWR x30_n16 sky130_fd_sc_hd__inv_1
X30_inv17 x30_n16 0 0 VPWR VPWR x30_n17 sky130_fd_sc_hd__inv_1
X30_inv18 x30_n17 0 0 VPWR VPWR x30_n18 sky130_fd_sc_hd__inv_1
X30_inv19 x30_n18 0 0 VPWR VPWR x30_n19 sky130_fd_sc_hd__inv_1
X30_inv20 x30_n19 0 0 VPWR VPWR x30_n20 sky130_fd_sc_hd__inv_1
X30_inv21 x30_n20 0 0 VPWR VPWR x30_n21 sky130_fd_sc_hd__inv_1
X30_inv22 x30_n21 0 0 VPWR VPWR x30_n22 sky130_fd_sc_hd__inv_1
X30_inv23 x30_n22 0 0 VPWR VPWR x30_n23 sky130_fd_sc_hd__inv_1
X30_inv24 x30_n23 0 0 VPWR VPWR x30_n24 sky130_fd_sc_hd__inv_1
X30_inv25 x30_n24 0 0 VPWR VPWR x30_n25 sky130_fd_sc_hd__inv_1
X30_inv26 x30_n25 0 0 VPWR VPWR x30_n26 sky130_fd_sc_hd__inv_1
X30_inv27 x30_n26 0 0 VPWR VPWR x30_n27 sky130_fd_sc_hd__inv_1
X30_inv28 x30_n27 0 0 VPWR VPWR x30_n28 sky130_fd_sc_hd__inv_1
X30_inv29 x30_n28 0 0 VPWR VPWR x30_n29 sky130_fd_sc_hd__inv_1
X30_inv30 x30_n29 0 0 VPWR VPWR x30_n30 sky130_fd_sc_hd__inv_1
X30_buf x30_n15 0 0 VPWR VPWR x30_out sky130_fd_sc_hd__buf_1
C30_n0 x30_n0 0 2.583710e-16
C30_n1 x30_n1 0 1.250960e-16
C30_n2 x30_n2 0 1.250960e-16
C30_n3 x30_n3 0 1.250960e-16
C30_n4 x30_n4 0 4.212590e-16
C30_n5 x30_n5 0 1.766030e-16
C30_n6 x30_n6 0 1.767380e-16
C30_n7 x30_n7 0 1.768470e-16
C30_n8 x30_n8 0 1.782080e-16
C30_n9 x30_n9 0 1.749310e-16
C30_n10 x30_n10 0 1.747980e-16
C30_n11 x30_n11 0 1.747980e-16
C30_n12 x30_n12 0 2.125310e-16
C30_n13 x30_n13 0 2.992350e-16
C30_n14 x30_n14 0 7.884850e-16
C30_n15 x30_n15 0 4.748460e-15
C30_n16 x30_n16 0 1.829260e-16
C30_n17 x30_n17 0 1.263090e-16
C30_n18 x30_n18 0 3.716920e-16
C30_n19 x30_n19 0 2.183610e-16
C30_n20 x30_n20 0 1.574940e-16
C30_n21 x30_n21 0 3.238230e-16
C30_n22 x30_n22 0 1.067930e-16
C30_n23 x30_n23 0 1.067930e-16
C30_n24 x30_n24 0 1.233470e-16
C30_n25 x30_n25 0 1.067930e-16
C30_n26 x30_n26 0 1.067930e-16
C30_n27 x30_n27 0 1.067930e-16
C30_n28 x30_n28 0 5.412800e-16
C30_n29 x30_n29 0 1.564940e-16
C30_n30 x30_n30 0 5.694240e-16
C30_out x30_out 0 3.282290e-16
* --- RO 31 ---
X31_nand EN x31_n30 0 0 VPWR VPWR x31_n0 sky130_fd_sc_hd__nand2_1
X31_inv1 x31_n0 0 0 VPWR VPWR x31_n1 sky130_fd_sc_hd__inv_1
X31_inv2 x31_n1 0 0 VPWR VPWR x31_n2 sky130_fd_sc_hd__inv_1
X31_inv3 x31_n2 0 0 VPWR VPWR x31_n3 sky130_fd_sc_hd__inv_1
X31_inv4 x31_n3 0 0 VPWR VPWR x31_n4 sky130_fd_sc_hd__inv_1
X31_inv5 x31_n4 0 0 VPWR VPWR x31_n5 sky130_fd_sc_hd__inv_1
X31_inv6 x31_n5 0 0 VPWR VPWR x31_n6 sky130_fd_sc_hd__inv_1
X31_inv7 x31_n6 0 0 VPWR VPWR x31_n7 sky130_fd_sc_hd__inv_1
X31_inv8 x31_n7 0 0 VPWR VPWR x31_n8 sky130_fd_sc_hd__inv_1
X31_inv9 x31_n8 0 0 VPWR VPWR x31_n9 sky130_fd_sc_hd__inv_1
X31_inv10 x31_n9 0 0 VPWR VPWR x31_n10 sky130_fd_sc_hd__inv_1
X31_inv11 x31_n10 0 0 VPWR VPWR x31_n11 sky130_fd_sc_hd__inv_1
X31_inv12 x31_n11 0 0 VPWR VPWR x31_n12 sky130_fd_sc_hd__inv_1
X31_inv13 x31_n12 0 0 VPWR VPWR x31_n13 sky130_fd_sc_hd__inv_1
X31_inv14 x31_n13 0 0 VPWR VPWR x31_n14 sky130_fd_sc_hd__inv_1
X31_inv15 x31_n14 0 0 VPWR VPWR x31_n15 sky130_fd_sc_hd__inv_1
X31_inv16 x31_n15 0 0 VPWR VPWR x31_n16 sky130_fd_sc_hd__inv_1
X31_inv17 x31_n16 0 0 VPWR VPWR x31_n17 sky130_fd_sc_hd__inv_1
X31_inv18 x31_n17 0 0 VPWR VPWR x31_n18 sky130_fd_sc_hd__inv_1
X31_inv19 x31_n18 0 0 VPWR VPWR x31_n19 sky130_fd_sc_hd__inv_1
X31_inv20 x31_n19 0 0 VPWR VPWR x31_n20 sky130_fd_sc_hd__inv_1
X31_inv21 x31_n20 0 0 VPWR VPWR x31_n21 sky130_fd_sc_hd__inv_1
X31_inv22 x31_n21 0 0 VPWR VPWR x31_n22 sky130_fd_sc_hd__inv_1
X31_inv23 x31_n22 0 0 VPWR VPWR x31_n23 sky130_fd_sc_hd__inv_1
X31_inv24 x31_n23 0 0 VPWR VPWR x31_n24 sky130_fd_sc_hd__inv_1
X31_inv25 x31_n24 0 0 VPWR VPWR x31_n25 sky130_fd_sc_hd__inv_1
X31_inv26 x31_n25 0 0 VPWR VPWR x31_n26 sky130_fd_sc_hd__inv_1
X31_inv27 x31_n26 0 0 VPWR VPWR x31_n27 sky130_fd_sc_hd__inv_1
X31_inv28 x31_n27 0 0 VPWR VPWR x31_n28 sky130_fd_sc_hd__inv_1
X31_inv29 x31_n28 0 0 VPWR VPWR x31_n29 sky130_fd_sc_hd__inv_1
X31_inv30 x31_n29 0 0 VPWR VPWR x31_n30 sky130_fd_sc_hd__inv_1
X31_buf x31_n15 0 0 VPWR VPWR x31_out sky130_fd_sc_hd__buf_1
C31_n0 x31_n0 0 3.225530e-16
C31_n1 x31_n1 0 5.036270e-16
C31_n2 x31_n2 0 6.426990e-16
C31_n3 x31_n3 0 4.176190e-16
C31_n4 x31_n4 0 3.537000e-16
C31_n5 x31_n5 0 9.220600e-16
C31_n6 x31_n6 0 7.136190e-16
C31_n7 x31_n7 0 4.492130e-16
C31_n8 x31_n8 0 2.434040e-16
C31_n9 x31_n9 0 1.427320e-16
C31_n10 x31_n10 0 1.640130e-16
C31_n11 x31_n11 0 5.464450e-16
C31_n12 x31_n12 0 9.682650e-16
C31_n13 x31_n13 0 9.246090e-16
C31_n14 x31_n14 0 5.187330e-16
C31_n15 x31_n15 0 1.960600e-15
C31_n16 x31_n16 0 6.333990e-16
C31_n17 x31_n17 0 1.067930e-16
C31_n18 x31_n18 0 1.067930e-16
C31_n19 x31_n19 0 1.067930e-16
C31_n20 x31_n20 0 1.067930e-16
C31_n21 x31_n21 0 1.072980e-16
C31_n22 x31_n22 0 1.258720e-16
C31_n23 x31_n23 0 1.067930e-16
C31_n24 x31_n24 0 1.067930e-16
C31_n25 x31_n25 0 1.233470e-16
C31_n26 x31_n26 0 6.103430e-16
C31_n27 x31_n27 0 2.487320e-16
C31_n28 x31_n28 0 4.434610e-16
C31_n29 x31_n29 0 7.739140e-16
C31_n30 x31_n30 0 1.443600e-16
C31_out x31_out 0 4.503250e-16

.save v(x0_out) v(x1_out) v(x2_out) v(x3_out) v(x4_out) v(x5_out) v(x6_out) v(x7_out) v(x8_out) v(x9_out) v(x10_out) v(x11_out) v(x12_out) v(x13_out) v(x14_out) v(x15_out) v(x16_out) v(x17_out) v(x18_out) v(x19_out) v(x20_out) v(x21_out) v(x22_out) v(x23_out) v(x24_out) v(x25_out) v(x26_out) v(x27_out) v(x28_out) v(x29_out) v(x30_out) v(x31_out)
.tran 5p 80n
.control
run
meas tran tp0 TRIG v(x0_out) VAL=0.9 RISE=5 TARG v(x0_out) VAL=0.9 RISE=25
meas tran tp1 TRIG v(x1_out) VAL=0.9 RISE=5 TARG v(x1_out) VAL=0.9 RISE=25
meas tran tp2 TRIG v(x2_out) VAL=0.9 RISE=5 TARG v(x2_out) VAL=0.9 RISE=25
meas tran tp3 TRIG v(x3_out) VAL=0.9 RISE=5 TARG v(x3_out) VAL=0.9 RISE=25
meas tran tp4 TRIG v(x4_out) VAL=0.9 RISE=5 TARG v(x4_out) VAL=0.9 RISE=25
meas tran tp5 TRIG v(x5_out) VAL=0.9 RISE=5 TARG v(x5_out) VAL=0.9 RISE=25
meas tran tp6 TRIG v(x6_out) VAL=0.9 RISE=5 TARG v(x6_out) VAL=0.9 RISE=25
meas tran tp7 TRIG v(x7_out) VAL=0.9 RISE=5 TARG v(x7_out) VAL=0.9 RISE=25
meas tran tp8 TRIG v(x8_out) VAL=0.9 RISE=5 TARG v(x8_out) VAL=0.9 RISE=25
meas tran tp9 TRIG v(x9_out) VAL=0.9 RISE=5 TARG v(x9_out) VAL=0.9 RISE=25
meas tran tp10 TRIG v(x10_out) VAL=0.9 RISE=5 TARG v(x10_out) VAL=0.9 RISE=25
meas tran tp11 TRIG v(x11_out) VAL=0.9 RISE=5 TARG v(x11_out) VAL=0.9 RISE=25
meas tran tp12 TRIG v(x12_out) VAL=0.9 RISE=5 TARG v(x12_out) VAL=0.9 RISE=25
meas tran tp13 TRIG v(x13_out) VAL=0.9 RISE=5 TARG v(x13_out) VAL=0.9 RISE=25
meas tran tp14 TRIG v(x14_out) VAL=0.9 RISE=5 TARG v(x14_out) VAL=0.9 RISE=25
meas tran tp15 TRIG v(x15_out) VAL=0.9 RISE=5 TARG v(x15_out) VAL=0.9 RISE=25
meas tran tp16 TRIG v(x16_out) VAL=0.9 RISE=5 TARG v(x16_out) VAL=0.9 RISE=25
meas tran tp17 TRIG v(x17_out) VAL=0.9 RISE=5 TARG v(x17_out) VAL=0.9 RISE=25
meas tran tp18 TRIG v(x18_out) VAL=0.9 RISE=5 TARG v(x18_out) VAL=0.9 RISE=25
meas tran tp19 TRIG v(x19_out) VAL=0.9 RISE=5 TARG v(x19_out) VAL=0.9 RISE=25
meas tran tp20 TRIG v(x20_out) VAL=0.9 RISE=5 TARG v(x20_out) VAL=0.9 RISE=25
meas tran tp21 TRIG v(x21_out) VAL=0.9 RISE=5 TARG v(x21_out) VAL=0.9 RISE=25
meas tran tp22 TRIG v(x22_out) VAL=0.9 RISE=5 TARG v(x22_out) VAL=0.9 RISE=25
meas tran tp23 TRIG v(x23_out) VAL=0.9 RISE=5 TARG v(x23_out) VAL=0.9 RISE=25
meas tran tp24 TRIG v(x24_out) VAL=0.9 RISE=5 TARG v(x24_out) VAL=0.9 RISE=25
meas tran tp25 TRIG v(x25_out) VAL=0.9 RISE=5 TARG v(x25_out) VAL=0.9 RISE=25
meas tran tp26 TRIG v(x26_out) VAL=0.9 RISE=5 TARG v(x26_out) VAL=0.9 RISE=25
meas tran tp27 TRIG v(x27_out) VAL=0.9 RISE=5 TARG v(x27_out) VAL=0.9 RISE=25
meas tran tp28 TRIG v(x28_out) VAL=0.9 RISE=5 TARG v(x28_out) VAL=0.9 RISE=25
meas tran tp29 TRIG v(x29_out) VAL=0.9 RISE=5 TARG v(x29_out) VAL=0.9 RISE=25
meas tran tp30 TRIG v(x30_out) VAL=0.9 RISE=5 TARG v(x30_out) VAL=0.9 RISE=25
meas tran tp31 TRIG v(x31_out) VAL=0.9 RISE=5 TARG v(x31_out) VAL=0.9 RISE=25
let f0 = 20 / tp0
let f1 = 20 / tp1
let f2 = 20 / tp2
let f3 = 20 / tp3
let f4 = 20 / tp4
let f5 = 20 / tp5
let f6 = 20 / tp6
let f7 = 20 / tp7
let f8 = 20 / tp8
let f9 = 20 / tp9
let f10 = 20 / tp10
let f11 = 20 / tp11
let f12 = 20 / tp12
let f13 = 20 / tp13
let f14 = 20 / tp14
let f15 = 20 / tp15
let f16 = 20 / tp16
let f17 = 20 / tp17
let f18 = 20 / tp18
let f19 = 20 / tp19
let f20 = 20 / tp20
let f21 = 20 / tp21
let f22 = 20 / tp22
let f23 = 20 / tp23
let f24 = 20 / tp24
let f25 = 20 / tp25
let f26 = 20 / tp26
let f27 = 20 / tp27
let f28 = 20 / tp28
let f29 = 20 / tp29
let f30 = 20 / tp30
let f31 = 20 / tp31
print f0
print f1
print f2
print f3
print f4
print f5
print f6
print f7
print f8
print f9
print f10
print f11
print f12
print f13
print f14
print f15
print f16
print f17
print f18
print f19
print f20
print f21
print f22
print f23
print f24
print f25
print f26
print f27
print f28
print f29
print f30
print f31
.endc
.end
