* Pre-silicon lumped-C go/no-go: CONTROL (no parasitics), tt 27C 1.8V
* auto-generated by gen_dualarm_decks.py -- 16 Arm A ROs, enable-started
.lib "/home/pc/pdks/sky130A/libs.tech/ngspice/sky130.lib.spice" tt
.include "/home/pc/pdks/sky130A/libs.ref/sky130_fd_sc_hd/spice/sky130_fd_sc_hd.spice"
.param SUPPLY=1.8
Vdd VPWR 0 {SUPPLY}
Ven EN 0 PULSE(0 1.8 2n 50p 50p 1 2)

* --- RO 0 ---
X0_nand EN x0_n30 0 0 VPWR VPWR x0_n0 sky130_fd_sc_hd__nand2_1
X0_inv1 x0_n0 0 0 VPWR VPWR x0_n1 sky130_fd_sc_hd__inv_1
X0_inv2 x0_n1 0 0 VPWR VPWR x0_n2 sky130_fd_sc_hd__inv_1
X0_inv3 x0_n2 0 0 VPWR VPWR x0_n3 sky130_fd_sc_hd__inv_1
X0_inv4 x0_n3 0 0 VPWR VPWR x0_n4 sky130_fd_sc_hd__inv_1
X0_inv5 x0_n4 0 0 VPWR VPWR x0_n5 sky130_fd_sc_hd__inv_1
X0_inv6 x0_n5 0 0 VPWR VPWR x0_n6 sky130_fd_sc_hd__inv_1
X0_inv7 x0_n6 0 0 VPWR VPWR x0_n7 sky130_fd_sc_hd__inv_1
X0_inv8 x0_n7 0 0 VPWR VPWR x0_n8 sky130_fd_sc_hd__inv_1
X0_inv9 x0_n8 0 0 VPWR VPWR x0_n9 sky130_fd_sc_hd__inv_1
X0_inv10 x0_n9 0 0 VPWR VPWR x0_n10 sky130_fd_sc_hd__inv_1
X0_inv11 x0_n10 0 0 VPWR VPWR x0_n11 sky130_fd_sc_hd__inv_1
X0_inv12 x0_n11 0 0 VPWR VPWR x0_n12 sky130_fd_sc_hd__inv_1
X0_inv13 x0_n12 0 0 VPWR VPWR x0_n13 sky130_fd_sc_hd__inv_1
X0_inv14 x0_n13 0 0 VPWR VPWR x0_n14 sky130_fd_sc_hd__inv_1
X0_inv15 x0_n14 0 0 VPWR VPWR x0_n15 sky130_fd_sc_hd__inv_1
X0_inv16 x0_n15 0 0 VPWR VPWR x0_n16 sky130_fd_sc_hd__inv_1
X0_inv17 x0_n16 0 0 VPWR VPWR x0_n17 sky130_fd_sc_hd__inv_1
X0_inv18 x0_n17 0 0 VPWR VPWR x0_n18 sky130_fd_sc_hd__inv_1
X0_inv19 x0_n18 0 0 VPWR VPWR x0_n19 sky130_fd_sc_hd__inv_1
X0_inv20 x0_n19 0 0 VPWR VPWR x0_n20 sky130_fd_sc_hd__inv_1
X0_inv21 x0_n20 0 0 VPWR VPWR x0_n21 sky130_fd_sc_hd__inv_1
X0_inv22 x0_n21 0 0 VPWR VPWR x0_n22 sky130_fd_sc_hd__inv_1
X0_inv23 x0_n22 0 0 VPWR VPWR x0_n23 sky130_fd_sc_hd__inv_1
X0_inv24 x0_n23 0 0 VPWR VPWR x0_n24 sky130_fd_sc_hd__inv_1
X0_inv25 x0_n24 0 0 VPWR VPWR x0_n25 sky130_fd_sc_hd__inv_1
X0_inv26 x0_n25 0 0 VPWR VPWR x0_n26 sky130_fd_sc_hd__inv_1
X0_inv27 x0_n26 0 0 VPWR VPWR x0_n27 sky130_fd_sc_hd__inv_1
X0_inv28 x0_n27 0 0 VPWR VPWR x0_n28 sky130_fd_sc_hd__inv_1
X0_inv29 x0_n28 0 0 VPWR VPWR x0_n29 sky130_fd_sc_hd__inv_1
X0_inv30 x0_n29 0 0 VPWR VPWR x0_n30 sky130_fd_sc_hd__inv_1
X0_buf x0_n15 0 0 VPWR VPWR x0_out sky130_fd_sc_hd__buf_1
* --- RO 1 ---
X1_nand EN x1_n30 0 0 VPWR VPWR x1_n0 sky130_fd_sc_hd__nand2_1
X1_inv1 x1_n0 0 0 VPWR VPWR x1_n1 sky130_fd_sc_hd__inv_1
X1_inv2 x1_n1 0 0 VPWR VPWR x1_n2 sky130_fd_sc_hd__inv_1
X1_inv3 x1_n2 0 0 VPWR VPWR x1_n3 sky130_fd_sc_hd__inv_1
X1_inv4 x1_n3 0 0 VPWR VPWR x1_n4 sky130_fd_sc_hd__inv_1
X1_inv5 x1_n4 0 0 VPWR VPWR x1_n5 sky130_fd_sc_hd__inv_1
X1_inv6 x1_n5 0 0 VPWR VPWR x1_n6 sky130_fd_sc_hd__inv_1
X1_inv7 x1_n6 0 0 VPWR VPWR x1_n7 sky130_fd_sc_hd__inv_1
X1_inv8 x1_n7 0 0 VPWR VPWR x1_n8 sky130_fd_sc_hd__inv_1
X1_inv9 x1_n8 0 0 VPWR VPWR x1_n9 sky130_fd_sc_hd__inv_1
X1_inv10 x1_n9 0 0 VPWR VPWR x1_n10 sky130_fd_sc_hd__inv_1
X1_inv11 x1_n10 0 0 VPWR VPWR x1_n11 sky130_fd_sc_hd__inv_1
X1_inv12 x1_n11 0 0 VPWR VPWR x1_n12 sky130_fd_sc_hd__inv_1
X1_inv13 x1_n12 0 0 VPWR VPWR x1_n13 sky130_fd_sc_hd__inv_1
X1_inv14 x1_n13 0 0 VPWR VPWR x1_n14 sky130_fd_sc_hd__inv_1
X1_inv15 x1_n14 0 0 VPWR VPWR x1_n15 sky130_fd_sc_hd__inv_1
X1_inv16 x1_n15 0 0 VPWR VPWR x1_n16 sky130_fd_sc_hd__inv_1
X1_inv17 x1_n16 0 0 VPWR VPWR x1_n17 sky130_fd_sc_hd__inv_1
X1_inv18 x1_n17 0 0 VPWR VPWR x1_n18 sky130_fd_sc_hd__inv_1
X1_inv19 x1_n18 0 0 VPWR VPWR x1_n19 sky130_fd_sc_hd__inv_1
X1_inv20 x1_n19 0 0 VPWR VPWR x1_n20 sky130_fd_sc_hd__inv_1
X1_inv21 x1_n20 0 0 VPWR VPWR x1_n21 sky130_fd_sc_hd__inv_1
X1_inv22 x1_n21 0 0 VPWR VPWR x1_n22 sky130_fd_sc_hd__inv_1
X1_inv23 x1_n22 0 0 VPWR VPWR x1_n23 sky130_fd_sc_hd__inv_1
X1_inv24 x1_n23 0 0 VPWR VPWR x1_n24 sky130_fd_sc_hd__inv_1
X1_inv25 x1_n24 0 0 VPWR VPWR x1_n25 sky130_fd_sc_hd__inv_1
X1_inv26 x1_n25 0 0 VPWR VPWR x1_n26 sky130_fd_sc_hd__inv_1
X1_inv27 x1_n26 0 0 VPWR VPWR x1_n27 sky130_fd_sc_hd__inv_1
X1_inv28 x1_n27 0 0 VPWR VPWR x1_n28 sky130_fd_sc_hd__inv_1
X1_inv29 x1_n28 0 0 VPWR VPWR x1_n29 sky130_fd_sc_hd__inv_1
X1_inv30 x1_n29 0 0 VPWR VPWR x1_n30 sky130_fd_sc_hd__inv_1
X1_buf x1_n15 0 0 VPWR VPWR x1_out sky130_fd_sc_hd__buf_1
* --- RO 2 ---
X2_nand EN x2_n30 0 0 VPWR VPWR x2_n0 sky130_fd_sc_hd__nand2_1
X2_inv1 x2_n0 0 0 VPWR VPWR x2_n1 sky130_fd_sc_hd__inv_1
X2_inv2 x2_n1 0 0 VPWR VPWR x2_n2 sky130_fd_sc_hd__inv_1
X2_inv3 x2_n2 0 0 VPWR VPWR x2_n3 sky130_fd_sc_hd__inv_1
X2_inv4 x2_n3 0 0 VPWR VPWR x2_n4 sky130_fd_sc_hd__inv_1
X2_inv5 x2_n4 0 0 VPWR VPWR x2_n5 sky130_fd_sc_hd__inv_1
X2_inv6 x2_n5 0 0 VPWR VPWR x2_n6 sky130_fd_sc_hd__inv_1
X2_inv7 x2_n6 0 0 VPWR VPWR x2_n7 sky130_fd_sc_hd__inv_1
X2_inv8 x2_n7 0 0 VPWR VPWR x2_n8 sky130_fd_sc_hd__inv_1
X2_inv9 x2_n8 0 0 VPWR VPWR x2_n9 sky130_fd_sc_hd__inv_1
X2_inv10 x2_n9 0 0 VPWR VPWR x2_n10 sky130_fd_sc_hd__inv_1
X2_inv11 x2_n10 0 0 VPWR VPWR x2_n11 sky130_fd_sc_hd__inv_1
X2_inv12 x2_n11 0 0 VPWR VPWR x2_n12 sky130_fd_sc_hd__inv_1
X2_inv13 x2_n12 0 0 VPWR VPWR x2_n13 sky130_fd_sc_hd__inv_1
X2_inv14 x2_n13 0 0 VPWR VPWR x2_n14 sky130_fd_sc_hd__inv_1
X2_inv15 x2_n14 0 0 VPWR VPWR x2_n15 sky130_fd_sc_hd__inv_1
X2_inv16 x2_n15 0 0 VPWR VPWR x2_n16 sky130_fd_sc_hd__inv_1
X2_inv17 x2_n16 0 0 VPWR VPWR x2_n17 sky130_fd_sc_hd__inv_1
X2_inv18 x2_n17 0 0 VPWR VPWR x2_n18 sky130_fd_sc_hd__inv_1
X2_inv19 x2_n18 0 0 VPWR VPWR x2_n19 sky130_fd_sc_hd__inv_1
X2_inv20 x2_n19 0 0 VPWR VPWR x2_n20 sky130_fd_sc_hd__inv_1
X2_inv21 x2_n20 0 0 VPWR VPWR x2_n21 sky130_fd_sc_hd__inv_1
X2_inv22 x2_n21 0 0 VPWR VPWR x2_n22 sky130_fd_sc_hd__inv_1
X2_inv23 x2_n22 0 0 VPWR VPWR x2_n23 sky130_fd_sc_hd__inv_1
X2_inv24 x2_n23 0 0 VPWR VPWR x2_n24 sky130_fd_sc_hd__inv_1
X2_inv25 x2_n24 0 0 VPWR VPWR x2_n25 sky130_fd_sc_hd__inv_1
X2_inv26 x2_n25 0 0 VPWR VPWR x2_n26 sky130_fd_sc_hd__inv_1
X2_inv27 x2_n26 0 0 VPWR VPWR x2_n27 sky130_fd_sc_hd__inv_1
X2_inv28 x2_n27 0 0 VPWR VPWR x2_n28 sky130_fd_sc_hd__inv_1
X2_inv29 x2_n28 0 0 VPWR VPWR x2_n29 sky130_fd_sc_hd__inv_1
X2_inv30 x2_n29 0 0 VPWR VPWR x2_n30 sky130_fd_sc_hd__inv_1
X2_buf x2_n15 0 0 VPWR VPWR x2_out sky130_fd_sc_hd__buf_1
* --- RO 3 ---
X3_nand EN x3_n30 0 0 VPWR VPWR x3_n0 sky130_fd_sc_hd__nand2_1
X3_inv1 x3_n0 0 0 VPWR VPWR x3_n1 sky130_fd_sc_hd__inv_1
X3_inv2 x3_n1 0 0 VPWR VPWR x3_n2 sky130_fd_sc_hd__inv_1
X3_inv3 x3_n2 0 0 VPWR VPWR x3_n3 sky130_fd_sc_hd__inv_1
X3_inv4 x3_n3 0 0 VPWR VPWR x3_n4 sky130_fd_sc_hd__inv_1
X3_inv5 x3_n4 0 0 VPWR VPWR x3_n5 sky130_fd_sc_hd__inv_1
X3_inv6 x3_n5 0 0 VPWR VPWR x3_n6 sky130_fd_sc_hd__inv_1
X3_inv7 x3_n6 0 0 VPWR VPWR x3_n7 sky130_fd_sc_hd__inv_1
X3_inv8 x3_n7 0 0 VPWR VPWR x3_n8 sky130_fd_sc_hd__inv_1
X3_inv9 x3_n8 0 0 VPWR VPWR x3_n9 sky130_fd_sc_hd__inv_1
X3_inv10 x3_n9 0 0 VPWR VPWR x3_n10 sky130_fd_sc_hd__inv_1
X3_inv11 x3_n10 0 0 VPWR VPWR x3_n11 sky130_fd_sc_hd__inv_1
X3_inv12 x3_n11 0 0 VPWR VPWR x3_n12 sky130_fd_sc_hd__inv_1
X3_inv13 x3_n12 0 0 VPWR VPWR x3_n13 sky130_fd_sc_hd__inv_1
X3_inv14 x3_n13 0 0 VPWR VPWR x3_n14 sky130_fd_sc_hd__inv_1
X3_inv15 x3_n14 0 0 VPWR VPWR x3_n15 sky130_fd_sc_hd__inv_1
X3_inv16 x3_n15 0 0 VPWR VPWR x3_n16 sky130_fd_sc_hd__inv_1
X3_inv17 x3_n16 0 0 VPWR VPWR x3_n17 sky130_fd_sc_hd__inv_1
X3_inv18 x3_n17 0 0 VPWR VPWR x3_n18 sky130_fd_sc_hd__inv_1
X3_inv19 x3_n18 0 0 VPWR VPWR x3_n19 sky130_fd_sc_hd__inv_1
X3_inv20 x3_n19 0 0 VPWR VPWR x3_n20 sky130_fd_sc_hd__inv_1
X3_inv21 x3_n20 0 0 VPWR VPWR x3_n21 sky130_fd_sc_hd__inv_1
X3_inv22 x3_n21 0 0 VPWR VPWR x3_n22 sky130_fd_sc_hd__inv_1
X3_inv23 x3_n22 0 0 VPWR VPWR x3_n23 sky130_fd_sc_hd__inv_1
X3_inv24 x3_n23 0 0 VPWR VPWR x3_n24 sky130_fd_sc_hd__inv_1
X3_inv25 x3_n24 0 0 VPWR VPWR x3_n25 sky130_fd_sc_hd__inv_1
X3_inv26 x3_n25 0 0 VPWR VPWR x3_n26 sky130_fd_sc_hd__inv_1
X3_inv27 x3_n26 0 0 VPWR VPWR x3_n27 sky130_fd_sc_hd__inv_1
X3_inv28 x3_n27 0 0 VPWR VPWR x3_n28 sky130_fd_sc_hd__inv_1
X3_inv29 x3_n28 0 0 VPWR VPWR x3_n29 sky130_fd_sc_hd__inv_1
X3_inv30 x3_n29 0 0 VPWR VPWR x3_n30 sky130_fd_sc_hd__inv_1
X3_buf x3_n15 0 0 VPWR VPWR x3_out sky130_fd_sc_hd__buf_1
* --- RO 4 ---
X4_nand EN x4_n30 0 0 VPWR VPWR x4_n0 sky130_fd_sc_hd__nand2_1
X4_inv1 x4_n0 0 0 VPWR VPWR x4_n1 sky130_fd_sc_hd__inv_1
X4_inv2 x4_n1 0 0 VPWR VPWR x4_n2 sky130_fd_sc_hd__inv_1
X4_inv3 x4_n2 0 0 VPWR VPWR x4_n3 sky130_fd_sc_hd__inv_1
X4_inv4 x4_n3 0 0 VPWR VPWR x4_n4 sky130_fd_sc_hd__inv_1
X4_inv5 x4_n4 0 0 VPWR VPWR x4_n5 sky130_fd_sc_hd__inv_1
X4_inv6 x4_n5 0 0 VPWR VPWR x4_n6 sky130_fd_sc_hd__inv_1
X4_inv7 x4_n6 0 0 VPWR VPWR x4_n7 sky130_fd_sc_hd__inv_1
X4_inv8 x4_n7 0 0 VPWR VPWR x4_n8 sky130_fd_sc_hd__inv_1
X4_inv9 x4_n8 0 0 VPWR VPWR x4_n9 sky130_fd_sc_hd__inv_1
X4_inv10 x4_n9 0 0 VPWR VPWR x4_n10 sky130_fd_sc_hd__inv_1
X4_inv11 x4_n10 0 0 VPWR VPWR x4_n11 sky130_fd_sc_hd__inv_1
X4_inv12 x4_n11 0 0 VPWR VPWR x4_n12 sky130_fd_sc_hd__inv_1
X4_inv13 x4_n12 0 0 VPWR VPWR x4_n13 sky130_fd_sc_hd__inv_1
X4_inv14 x4_n13 0 0 VPWR VPWR x4_n14 sky130_fd_sc_hd__inv_1
X4_inv15 x4_n14 0 0 VPWR VPWR x4_n15 sky130_fd_sc_hd__inv_1
X4_inv16 x4_n15 0 0 VPWR VPWR x4_n16 sky130_fd_sc_hd__inv_1
X4_inv17 x4_n16 0 0 VPWR VPWR x4_n17 sky130_fd_sc_hd__inv_1
X4_inv18 x4_n17 0 0 VPWR VPWR x4_n18 sky130_fd_sc_hd__inv_1
X4_inv19 x4_n18 0 0 VPWR VPWR x4_n19 sky130_fd_sc_hd__inv_1
X4_inv20 x4_n19 0 0 VPWR VPWR x4_n20 sky130_fd_sc_hd__inv_1
X4_inv21 x4_n20 0 0 VPWR VPWR x4_n21 sky130_fd_sc_hd__inv_1
X4_inv22 x4_n21 0 0 VPWR VPWR x4_n22 sky130_fd_sc_hd__inv_1
X4_inv23 x4_n22 0 0 VPWR VPWR x4_n23 sky130_fd_sc_hd__inv_1
X4_inv24 x4_n23 0 0 VPWR VPWR x4_n24 sky130_fd_sc_hd__inv_1
X4_inv25 x4_n24 0 0 VPWR VPWR x4_n25 sky130_fd_sc_hd__inv_1
X4_inv26 x4_n25 0 0 VPWR VPWR x4_n26 sky130_fd_sc_hd__inv_1
X4_inv27 x4_n26 0 0 VPWR VPWR x4_n27 sky130_fd_sc_hd__inv_1
X4_inv28 x4_n27 0 0 VPWR VPWR x4_n28 sky130_fd_sc_hd__inv_1
X4_inv29 x4_n28 0 0 VPWR VPWR x4_n29 sky130_fd_sc_hd__inv_1
X4_inv30 x4_n29 0 0 VPWR VPWR x4_n30 sky130_fd_sc_hd__inv_1
X4_buf x4_n15 0 0 VPWR VPWR x4_out sky130_fd_sc_hd__buf_1
* --- RO 5 ---
X5_nand EN x5_n30 0 0 VPWR VPWR x5_n0 sky130_fd_sc_hd__nand2_1
X5_inv1 x5_n0 0 0 VPWR VPWR x5_n1 sky130_fd_sc_hd__inv_1
X5_inv2 x5_n1 0 0 VPWR VPWR x5_n2 sky130_fd_sc_hd__inv_1
X5_inv3 x5_n2 0 0 VPWR VPWR x5_n3 sky130_fd_sc_hd__inv_1
X5_inv4 x5_n3 0 0 VPWR VPWR x5_n4 sky130_fd_sc_hd__inv_1
X5_inv5 x5_n4 0 0 VPWR VPWR x5_n5 sky130_fd_sc_hd__inv_1
X5_inv6 x5_n5 0 0 VPWR VPWR x5_n6 sky130_fd_sc_hd__inv_1
X5_inv7 x5_n6 0 0 VPWR VPWR x5_n7 sky130_fd_sc_hd__inv_1
X5_inv8 x5_n7 0 0 VPWR VPWR x5_n8 sky130_fd_sc_hd__inv_1
X5_inv9 x5_n8 0 0 VPWR VPWR x5_n9 sky130_fd_sc_hd__inv_1
X5_inv10 x5_n9 0 0 VPWR VPWR x5_n10 sky130_fd_sc_hd__inv_1
X5_inv11 x5_n10 0 0 VPWR VPWR x5_n11 sky130_fd_sc_hd__inv_1
X5_inv12 x5_n11 0 0 VPWR VPWR x5_n12 sky130_fd_sc_hd__inv_1
X5_inv13 x5_n12 0 0 VPWR VPWR x5_n13 sky130_fd_sc_hd__inv_1
X5_inv14 x5_n13 0 0 VPWR VPWR x5_n14 sky130_fd_sc_hd__inv_1
X5_inv15 x5_n14 0 0 VPWR VPWR x5_n15 sky130_fd_sc_hd__inv_1
X5_inv16 x5_n15 0 0 VPWR VPWR x5_n16 sky130_fd_sc_hd__inv_1
X5_inv17 x5_n16 0 0 VPWR VPWR x5_n17 sky130_fd_sc_hd__inv_1
X5_inv18 x5_n17 0 0 VPWR VPWR x5_n18 sky130_fd_sc_hd__inv_1
X5_inv19 x5_n18 0 0 VPWR VPWR x5_n19 sky130_fd_sc_hd__inv_1
X5_inv20 x5_n19 0 0 VPWR VPWR x5_n20 sky130_fd_sc_hd__inv_1
X5_inv21 x5_n20 0 0 VPWR VPWR x5_n21 sky130_fd_sc_hd__inv_1
X5_inv22 x5_n21 0 0 VPWR VPWR x5_n22 sky130_fd_sc_hd__inv_1
X5_inv23 x5_n22 0 0 VPWR VPWR x5_n23 sky130_fd_sc_hd__inv_1
X5_inv24 x5_n23 0 0 VPWR VPWR x5_n24 sky130_fd_sc_hd__inv_1
X5_inv25 x5_n24 0 0 VPWR VPWR x5_n25 sky130_fd_sc_hd__inv_1
X5_inv26 x5_n25 0 0 VPWR VPWR x5_n26 sky130_fd_sc_hd__inv_1
X5_inv27 x5_n26 0 0 VPWR VPWR x5_n27 sky130_fd_sc_hd__inv_1
X5_inv28 x5_n27 0 0 VPWR VPWR x5_n28 sky130_fd_sc_hd__inv_1
X5_inv29 x5_n28 0 0 VPWR VPWR x5_n29 sky130_fd_sc_hd__inv_1
X5_inv30 x5_n29 0 0 VPWR VPWR x5_n30 sky130_fd_sc_hd__inv_1
X5_buf x5_n15 0 0 VPWR VPWR x5_out sky130_fd_sc_hd__buf_1
* --- RO 6 ---
X6_nand EN x6_n30 0 0 VPWR VPWR x6_n0 sky130_fd_sc_hd__nand2_1
X6_inv1 x6_n0 0 0 VPWR VPWR x6_n1 sky130_fd_sc_hd__inv_1
X6_inv2 x6_n1 0 0 VPWR VPWR x6_n2 sky130_fd_sc_hd__inv_1
X6_inv3 x6_n2 0 0 VPWR VPWR x6_n3 sky130_fd_sc_hd__inv_1
X6_inv4 x6_n3 0 0 VPWR VPWR x6_n4 sky130_fd_sc_hd__inv_1
X6_inv5 x6_n4 0 0 VPWR VPWR x6_n5 sky130_fd_sc_hd__inv_1
X6_inv6 x6_n5 0 0 VPWR VPWR x6_n6 sky130_fd_sc_hd__inv_1
X6_inv7 x6_n6 0 0 VPWR VPWR x6_n7 sky130_fd_sc_hd__inv_1
X6_inv8 x6_n7 0 0 VPWR VPWR x6_n8 sky130_fd_sc_hd__inv_1
X6_inv9 x6_n8 0 0 VPWR VPWR x6_n9 sky130_fd_sc_hd__inv_1
X6_inv10 x6_n9 0 0 VPWR VPWR x6_n10 sky130_fd_sc_hd__inv_1
X6_inv11 x6_n10 0 0 VPWR VPWR x6_n11 sky130_fd_sc_hd__inv_1
X6_inv12 x6_n11 0 0 VPWR VPWR x6_n12 sky130_fd_sc_hd__inv_1
X6_inv13 x6_n12 0 0 VPWR VPWR x6_n13 sky130_fd_sc_hd__inv_1
X6_inv14 x6_n13 0 0 VPWR VPWR x6_n14 sky130_fd_sc_hd__inv_1
X6_inv15 x6_n14 0 0 VPWR VPWR x6_n15 sky130_fd_sc_hd__inv_1
X6_inv16 x6_n15 0 0 VPWR VPWR x6_n16 sky130_fd_sc_hd__inv_1
X6_inv17 x6_n16 0 0 VPWR VPWR x6_n17 sky130_fd_sc_hd__inv_1
X6_inv18 x6_n17 0 0 VPWR VPWR x6_n18 sky130_fd_sc_hd__inv_1
X6_inv19 x6_n18 0 0 VPWR VPWR x6_n19 sky130_fd_sc_hd__inv_1
X6_inv20 x6_n19 0 0 VPWR VPWR x6_n20 sky130_fd_sc_hd__inv_1
X6_inv21 x6_n20 0 0 VPWR VPWR x6_n21 sky130_fd_sc_hd__inv_1
X6_inv22 x6_n21 0 0 VPWR VPWR x6_n22 sky130_fd_sc_hd__inv_1
X6_inv23 x6_n22 0 0 VPWR VPWR x6_n23 sky130_fd_sc_hd__inv_1
X6_inv24 x6_n23 0 0 VPWR VPWR x6_n24 sky130_fd_sc_hd__inv_1
X6_inv25 x6_n24 0 0 VPWR VPWR x6_n25 sky130_fd_sc_hd__inv_1
X6_inv26 x6_n25 0 0 VPWR VPWR x6_n26 sky130_fd_sc_hd__inv_1
X6_inv27 x6_n26 0 0 VPWR VPWR x6_n27 sky130_fd_sc_hd__inv_1
X6_inv28 x6_n27 0 0 VPWR VPWR x6_n28 sky130_fd_sc_hd__inv_1
X6_inv29 x6_n28 0 0 VPWR VPWR x6_n29 sky130_fd_sc_hd__inv_1
X6_inv30 x6_n29 0 0 VPWR VPWR x6_n30 sky130_fd_sc_hd__inv_1
X6_buf x6_n15 0 0 VPWR VPWR x6_out sky130_fd_sc_hd__buf_1
* --- RO 7 ---
X7_nand EN x7_n30 0 0 VPWR VPWR x7_n0 sky130_fd_sc_hd__nand2_1
X7_inv1 x7_n0 0 0 VPWR VPWR x7_n1 sky130_fd_sc_hd__inv_1
X7_inv2 x7_n1 0 0 VPWR VPWR x7_n2 sky130_fd_sc_hd__inv_1
X7_inv3 x7_n2 0 0 VPWR VPWR x7_n3 sky130_fd_sc_hd__inv_1
X7_inv4 x7_n3 0 0 VPWR VPWR x7_n4 sky130_fd_sc_hd__inv_1
X7_inv5 x7_n4 0 0 VPWR VPWR x7_n5 sky130_fd_sc_hd__inv_1
X7_inv6 x7_n5 0 0 VPWR VPWR x7_n6 sky130_fd_sc_hd__inv_1
X7_inv7 x7_n6 0 0 VPWR VPWR x7_n7 sky130_fd_sc_hd__inv_1
X7_inv8 x7_n7 0 0 VPWR VPWR x7_n8 sky130_fd_sc_hd__inv_1
X7_inv9 x7_n8 0 0 VPWR VPWR x7_n9 sky130_fd_sc_hd__inv_1
X7_inv10 x7_n9 0 0 VPWR VPWR x7_n10 sky130_fd_sc_hd__inv_1
X7_inv11 x7_n10 0 0 VPWR VPWR x7_n11 sky130_fd_sc_hd__inv_1
X7_inv12 x7_n11 0 0 VPWR VPWR x7_n12 sky130_fd_sc_hd__inv_1
X7_inv13 x7_n12 0 0 VPWR VPWR x7_n13 sky130_fd_sc_hd__inv_1
X7_inv14 x7_n13 0 0 VPWR VPWR x7_n14 sky130_fd_sc_hd__inv_1
X7_inv15 x7_n14 0 0 VPWR VPWR x7_n15 sky130_fd_sc_hd__inv_1
X7_inv16 x7_n15 0 0 VPWR VPWR x7_n16 sky130_fd_sc_hd__inv_1
X7_inv17 x7_n16 0 0 VPWR VPWR x7_n17 sky130_fd_sc_hd__inv_1
X7_inv18 x7_n17 0 0 VPWR VPWR x7_n18 sky130_fd_sc_hd__inv_1
X7_inv19 x7_n18 0 0 VPWR VPWR x7_n19 sky130_fd_sc_hd__inv_1
X7_inv20 x7_n19 0 0 VPWR VPWR x7_n20 sky130_fd_sc_hd__inv_1
X7_inv21 x7_n20 0 0 VPWR VPWR x7_n21 sky130_fd_sc_hd__inv_1
X7_inv22 x7_n21 0 0 VPWR VPWR x7_n22 sky130_fd_sc_hd__inv_1
X7_inv23 x7_n22 0 0 VPWR VPWR x7_n23 sky130_fd_sc_hd__inv_1
X7_inv24 x7_n23 0 0 VPWR VPWR x7_n24 sky130_fd_sc_hd__inv_1
X7_inv25 x7_n24 0 0 VPWR VPWR x7_n25 sky130_fd_sc_hd__inv_1
X7_inv26 x7_n25 0 0 VPWR VPWR x7_n26 sky130_fd_sc_hd__inv_1
X7_inv27 x7_n26 0 0 VPWR VPWR x7_n27 sky130_fd_sc_hd__inv_1
X7_inv28 x7_n27 0 0 VPWR VPWR x7_n28 sky130_fd_sc_hd__inv_1
X7_inv29 x7_n28 0 0 VPWR VPWR x7_n29 sky130_fd_sc_hd__inv_1
X7_inv30 x7_n29 0 0 VPWR VPWR x7_n30 sky130_fd_sc_hd__inv_1
X7_buf x7_n15 0 0 VPWR VPWR x7_out sky130_fd_sc_hd__buf_1
* --- RO 8 ---
X8_nand EN x8_n30 0 0 VPWR VPWR x8_n0 sky130_fd_sc_hd__nand2_1
X8_inv1 x8_n0 0 0 VPWR VPWR x8_n1 sky130_fd_sc_hd__inv_1
X8_inv2 x8_n1 0 0 VPWR VPWR x8_n2 sky130_fd_sc_hd__inv_1
X8_inv3 x8_n2 0 0 VPWR VPWR x8_n3 sky130_fd_sc_hd__inv_1
X8_inv4 x8_n3 0 0 VPWR VPWR x8_n4 sky130_fd_sc_hd__inv_1
X8_inv5 x8_n4 0 0 VPWR VPWR x8_n5 sky130_fd_sc_hd__inv_1
X8_inv6 x8_n5 0 0 VPWR VPWR x8_n6 sky130_fd_sc_hd__inv_1
X8_inv7 x8_n6 0 0 VPWR VPWR x8_n7 sky130_fd_sc_hd__inv_1
X8_inv8 x8_n7 0 0 VPWR VPWR x8_n8 sky130_fd_sc_hd__inv_1
X8_inv9 x8_n8 0 0 VPWR VPWR x8_n9 sky130_fd_sc_hd__inv_1
X8_inv10 x8_n9 0 0 VPWR VPWR x8_n10 sky130_fd_sc_hd__inv_1
X8_inv11 x8_n10 0 0 VPWR VPWR x8_n11 sky130_fd_sc_hd__inv_1
X8_inv12 x8_n11 0 0 VPWR VPWR x8_n12 sky130_fd_sc_hd__inv_1
X8_inv13 x8_n12 0 0 VPWR VPWR x8_n13 sky130_fd_sc_hd__inv_1
X8_inv14 x8_n13 0 0 VPWR VPWR x8_n14 sky130_fd_sc_hd__inv_1
X8_inv15 x8_n14 0 0 VPWR VPWR x8_n15 sky130_fd_sc_hd__inv_1
X8_inv16 x8_n15 0 0 VPWR VPWR x8_n16 sky130_fd_sc_hd__inv_1
X8_inv17 x8_n16 0 0 VPWR VPWR x8_n17 sky130_fd_sc_hd__inv_1
X8_inv18 x8_n17 0 0 VPWR VPWR x8_n18 sky130_fd_sc_hd__inv_1
X8_inv19 x8_n18 0 0 VPWR VPWR x8_n19 sky130_fd_sc_hd__inv_1
X8_inv20 x8_n19 0 0 VPWR VPWR x8_n20 sky130_fd_sc_hd__inv_1
X8_inv21 x8_n20 0 0 VPWR VPWR x8_n21 sky130_fd_sc_hd__inv_1
X8_inv22 x8_n21 0 0 VPWR VPWR x8_n22 sky130_fd_sc_hd__inv_1
X8_inv23 x8_n22 0 0 VPWR VPWR x8_n23 sky130_fd_sc_hd__inv_1
X8_inv24 x8_n23 0 0 VPWR VPWR x8_n24 sky130_fd_sc_hd__inv_1
X8_inv25 x8_n24 0 0 VPWR VPWR x8_n25 sky130_fd_sc_hd__inv_1
X8_inv26 x8_n25 0 0 VPWR VPWR x8_n26 sky130_fd_sc_hd__inv_1
X8_inv27 x8_n26 0 0 VPWR VPWR x8_n27 sky130_fd_sc_hd__inv_1
X8_inv28 x8_n27 0 0 VPWR VPWR x8_n28 sky130_fd_sc_hd__inv_1
X8_inv29 x8_n28 0 0 VPWR VPWR x8_n29 sky130_fd_sc_hd__inv_1
X8_inv30 x8_n29 0 0 VPWR VPWR x8_n30 sky130_fd_sc_hd__inv_1
X8_buf x8_n15 0 0 VPWR VPWR x8_out sky130_fd_sc_hd__buf_1
* --- RO 9 ---
X9_nand EN x9_n30 0 0 VPWR VPWR x9_n0 sky130_fd_sc_hd__nand2_1
X9_inv1 x9_n0 0 0 VPWR VPWR x9_n1 sky130_fd_sc_hd__inv_1
X9_inv2 x9_n1 0 0 VPWR VPWR x9_n2 sky130_fd_sc_hd__inv_1
X9_inv3 x9_n2 0 0 VPWR VPWR x9_n3 sky130_fd_sc_hd__inv_1
X9_inv4 x9_n3 0 0 VPWR VPWR x9_n4 sky130_fd_sc_hd__inv_1
X9_inv5 x9_n4 0 0 VPWR VPWR x9_n5 sky130_fd_sc_hd__inv_1
X9_inv6 x9_n5 0 0 VPWR VPWR x9_n6 sky130_fd_sc_hd__inv_1
X9_inv7 x9_n6 0 0 VPWR VPWR x9_n7 sky130_fd_sc_hd__inv_1
X9_inv8 x9_n7 0 0 VPWR VPWR x9_n8 sky130_fd_sc_hd__inv_1
X9_inv9 x9_n8 0 0 VPWR VPWR x9_n9 sky130_fd_sc_hd__inv_1
X9_inv10 x9_n9 0 0 VPWR VPWR x9_n10 sky130_fd_sc_hd__inv_1
X9_inv11 x9_n10 0 0 VPWR VPWR x9_n11 sky130_fd_sc_hd__inv_1
X9_inv12 x9_n11 0 0 VPWR VPWR x9_n12 sky130_fd_sc_hd__inv_1
X9_inv13 x9_n12 0 0 VPWR VPWR x9_n13 sky130_fd_sc_hd__inv_1
X9_inv14 x9_n13 0 0 VPWR VPWR x9_n14 sky130_fd_sc_hd__inv_1
X9_inv15 x9_n14 0 0 VPWR VPWR x9_n15 sky130_fd_sc_hd__inv_1
X9_inv16 x9_n15 0 0 VPWR VPWR x9_n16 sky130_fd_sc_hd__inv_1
X9_inv17 x9_n16 0 0 VPWR VPWR x9_n17 sky130_fd_sc_hd__inv_1
X9_inv18 x9_n17 0 0 VPWR VPWR x9_n18 sky130_fd_sc_hd__inv_1
X9_inv19 x9_n18 0 0 VPWR VPWR x9_n19 sky130_fd_sc_hd__inv_1
X9_inv20 x9_n19 0 0 VPWR VPWR x9_n20 sky130_fd_sc_hd__inv_1
X9_inv21 x9_n20 0 0 VPWR VPWR x9_n21 sky130_fd_sc_hd__inv_1
X9_inv22 x9_n21 0 0 VPWR VPWR x9_n22 sky130_fd_sc_hd__inv_1
X9_inv23 x9_n22 0 0 VPWR VPWR x9_n23 sky130_fd_sc_hd__inv_1
X9_inv24 x9_n23 0 0 VPWR VPWR x9_n24 sky130_fd_sc_hd__inv_1
X9_inv25 x9_n24 0 0 VPWR VPWR x9_n25 sky130_fd_sc_hd__inv_1
X9_inv26 x9_n25 0 0 VPWR VPWR x9_n26 sky130_fd_sc_hd__inv_1
X9_inv27 x9_n26 0 0 VPWR VPWR x9_n27 sky130_fd_sc_hd__inv_1
X9_inv28 x9_n27 0 0 VPWR VPWR x9_n28 sky130_fd_sc_hd__inv_1
X9_inv29 x9_n28 0 0 VPWR VPWR x9_n29 sky130_fd_sc_hd__inv_1
X9_inv30 x9_n29 0 0 VPWR VPWR x9_n30 sky130_fd_sc_hd__inv_1
X9_buf x9_n15 0 0 VPWR VPWR x9_out sky130_fd_sc_hd__buf_1
* --- RO 10 ---
X10_nand EN x10_n30 0 0 VPWR VPWR x10_n0 sky130_fd_sc_hd__nand2_1
X10_inv1 x10_n0 0 0 VPWR VPWR x10_n1 sky130_fd_sc_hd__inv_1
X10_inv2 x10_n1 0 0 VPWR VPWR x10_n2 sky130_fd_sc_hd__inv_1
X10_inv3 x10_n2 0 0 VPWR VPWR x10_n3 sky130_fd_sc_hd__inv_1
X10_inv4 x10_n3 0 0 VPWR VPWR x10_n4 sky130_fd_sc_hd__inv_1
X10_inv5 x10_n4 0 0 VPWR VPWR x10_n5 sky130_fd_sc_hd__inv_1
X10_inv6 x10_n5 0 0 VPWR VPWR x10_n6 sky130_fd_sc_hd__inv_1
X10_inv7 x10_n6 0 0 VPWR VPWR x10_n7 sky130_fd_sc_hd__inv_1
X10_inv8 x10_n7 0 0 VPWR VPWR x10_n8 sky130_fd_sc_hd__inv_1
X10_inv9 x10_n8 0 0 VPWR VPWR x10_n9 sky130_fd_sc_hd__inv_1
X10_inv10 x10_n9 0 0 VPWR VPWR x10_n10 sky130_fd_sc_hd__inv_1
X10_inv11 x10_n10 0 0 VPWR VPWR x10_n11 sky130_fd_sc_hd__inv_1
X10_inv12 x10_n11 0 0 VPWR VPWR x10_n12 sky130_fd_sc_hd__inv_1
X10_inv13 x10_n12 0 0 VPWR VPWR x10_n13 sky130_fd_sc_hd__inv_1
X10_inv14 x10_n13 0 0 VPWR VPWR x10_n14 sky130_fd_sc_hd__inv_1
X10_inv15 x10_n14 0 0 VPWR VPWR x10_n15 sky130_fd_sc_hd__inv_1
X10_inv16 x10_n15 0 0 VPWR VPWR x10_n16 sky130_fd_sc_hd__inv_1
X10_inv17 x10_n16 0 0 VPWR VPWR x10_n17 sky130_fd_sc_hd__inv_1
X10_inv18 x10_n17 0 0 VPWR VPWR x10_n18 sky130_fd_sc_hd__inv_1
X10_inv19 x10_n18 0 0 VPWR VPWR x10_n19 sky130_fd_sc_hd__inv_1
X10_inv20 x10_n19 0 0 VPWR VPWR x10_n20 sky130_fd_sc_hd__inv_1
X10_inv21 x10_n20 0 0 VPWR VPWR x10_n21 sky130_fd_sc_hd__inv_1
X10_inv22 x10_n21 0 0 VPWR VPWR x10_n22 sky130_fd_sc_hd__inv_1
X10_inv23 x10_n22 0 0 VPWR VPWR x10_n23 sky130_fd_sc_hd__inv_1
X10_inv24 x10_n23 0 0 VPWR VPWR x10_n24 sky130_fd_sc_hd__inv_1
X10_inv25 x10_n24 0 0 VPWR VPWR x10_n25 sky130_fd_sc_hd__inv_1
X10_inv26 x10_n25 0 0 VPWR VPWR x10_n26 sky130_fd_sc_hd__inv_1
X10_inv27 x10_n26 0 0 VPWR VPWR x10_n27 sky130_fd_sc_hd__inv_1
X10_inv28 x10_n27 0 0 VPWR VPWR x10_n28 sky130_fd_sc_hd__inv_1
X10_inv29 x10_n28 0 0 VPWR VPWR x10_n29 sky130_fd_sc_hd__inv_1
X10_inv30 x10_n29 0 0 VPWR VPWR x10_n30 sky130_fd_sc_hd__inv_1
X10_buf x10_n15 0 0 VPWR VPWR x10_out sky130_fd_sc_hd__buf_1
* --- RO 11 ---
X11_nand EN x11_n30 0 0 VPWR VPWR x11_n0 sky130_fd_sc_hd__nand2_1
X11_inv1 x11_n0 0 0 VPWR VPWR x11_n1 sky130_fd_sc_hd__inv_1
X11_inv2 x11_n1 0 0 VPWR VPWR x11_n2 sky130_fd_sc_hd__inv_1
X11_inv3 x11_n2 0 0 VPWR VPWR x11_n3 sky130_fd_sc_hd__inv_1
X11_inv4 x11_n3 0 0 VPWR VPWR x11_n4 sky130_fd_sc_hd__inv_1
X11_inv5 x11_n4 0 0 VPWR VPWR x11_n5 sky130_fd_sc_hd__inv_1
X11_inv6 x11_n5 0 0 VPWR VPWR x11_n6 sky130_fd_sc_hd__inv_1
X11_inv7 x11_n6 0 0 VPWR VPWR x11_n7 sky130_fd_sc_hd__inv_1
X11_inv8 x11_n7 0 0 VPWR VPWR x11_n8 sky130_fd_sc_hd__inv_1
X11_inv9 x11_n8 0 0 VPWR VPWR x11_n9 sky130_fd_sc_hd__inv_1
X11_inv10 x11_n9 0 0 VPWR VPWR x11_n10 sky130_fd_sc_hd__inv_1
X11_inv11 x11_n10 0 0 VPWR VPWR x11_n11 sky130_fd_sc_hd__inv_1
X11_inv12 x11_n11 0 0 VPWR VPWR x11_n12 sky130_fd_sc_hd__inv_1
X11_inv13 x11_n12 0 0 VPWR VPWR x11_n13 sky130_fd_sc_hd__inv_1
X11_inv14 x11_n13 0 0 VPWR VPWR x11_n14 sky130_fd_sc_hd__inv_1
X11_inv15 x11_n14 0 0 VPWR VPWR x11_n15 sky130_fd_sc_hd__inv_1
X11_inv16 x11_n15 0 0 VPWR VPWR x11_n16 sky130_fd_sc_hd__inv_1
X11_inv17 x11_n16 0 0 VPWR VPWR x11_n17 sky130_fd_sc_hd__inv_1
X11_inv18 x11_n17 0 0 VPWR VPWR x11_n18 sky130_fd_sc_hd__inv_1
X11_inv19 x11_n18 0 0 VPWR VPWR x11_n19 sky130_fd_sc_hd__inv_1
X11_inv20 x11_n19 0 0 VPWR VPWR x11_n20 sky130_fd_sc_hd__inv_1
X11_inv21 x11_n20 0 0 VPWR VPWR x11_n21 sky130_fd_sc_hd__inv_1
X11_inv22 x11_n21 0 0 VPWR VPWR x11_n22 sky130_fd_sc_hd__inv_1
X11_inv23 x11_n22 0 0 VPWR VPWR x11_n23 sky130_fd_sc_hd__inv_1
X11_inv24 x11_n23 0 0 VPWR VPWR x11_n24 sky130_fd_sc_hd__inv_1
X11_inv25 x11_n24 0 0 VPWR VPWR x11_n25 sky130_fd_sc_hd__inv_1
X11_inv26 x11_n25 0 0 VPWR VPWR x11_n26 sky130_fd_sc_hd__inv_1
X11_inv27 x11_n26 0 0 VPWR VPWR x11_n27 sky130_fd_sc_hd__inv_1
X11_inv28 x11_n27 0 0 VPWR VPWR x11_n28 sky130_fd_sc_hd__inv_1
X11_inv29 x11_n28 0 0 VPWR VPWR x11_n29 sky130_fd_sc_hd__inv_1
X11_inv30 x11_n29 0 0 VPWR VPWR x11_n30 sky130_fd_sc_hd__inv_1
X11_buf x11_n15 0 0 VPWR VPWR x11_out sky130_fd_sc_hd__buf_1
* --- RO 12 ---
X12_nand EN x12_n30 0 0 VPWR VPWR x12_n0 sky130_fd_sc_hd__nand2_1
X12_inv1 x12_n0 0 0 VPWR VPWR x12_n1 sky130_fd_sc_hd__inv_1
X12_inv2 x12_n1 0 0 VPWR VPWR x12_n2 sky130_fd_sc_hd__inv_1
X12_inv3 x12_n2 0 0 VPWR VPWR x12_n3 sky130_fd_sc_hd__inv_1
X12_inv4 x12_n3 0 0 VPWR VPWR x12_n4 sky130_fd_sc_hd__inv_1
X12_inv5 x12_n4 0 0 VPWR VPWR x12_n5 sky130_fd_sc_hd__inv_1
X12_inv6 x12_n5 0 0 VPWR VPWR x12_n6 sky130_fd_sc_hd__inv_1
X12_inv7 x12_n6 0 0 VPWR VPWR x12_n7 sky130_fd_sc_hd__inv_1
X12_inv8 x12_n7 0 0 VPWR VPWR x12_n8 sky130_fd_sc_hd__inv_1
X12_inv9 x12_n8 0 0 VPWR VPWR x12_n9 sky130_fd_sc_hd__inv_1
X12_inv10 x12_n9 0 0 VPWR VPWR x12_n10 sky130_fd_sc_hd__inv_1
X12_inv11 x12_n10 0 0 VPWR VPWR x12_n11 sky130_fd_sc_hd__inv_1
X12_inv12 x12_n11 0 0 VPWR VPWR x12_n12 sky130_fd_sc_hd__inv_1
X12_inv13 x12_n12 0 0 VPWR VPWR x12_n13 sky130_fd_sc_hd__inv_1
X12_inv14 x12_n13 0 0 VPWR VPWR x12_n14 sky130_fd_sc_hd__inv_1
X12_inv15 x12_n14 0 0 VPWR VPWR x12_n15 sky130_fd_sc_hd__inv_1
X12_inv16 x12_n15 0 0 VPWR VPWR x12_n16 sky130_fd_sc_hd__inv_1
X12_inv17 x12_n16 0 0 VPWR VPWR x12_n17 sky130_fd_sc_hd__inv_1
X12_inv18 x12_n17 0 0 VPWR VPWR x12_n18 sky130_fd_sc_hd__inv_1
X12_inv19 x12_n18 0 0 VPWR VPWR x12_n19 sky130_fd_sc_hd__inv_1
X12_inv20 x12_n19 0 0 VPWR VPWR x12_n20 sky130_fd_sc_hd__inv_1
X12_inv21 x12_n20 0 0 VPWR VPWR x12_n21 sky130_fd_sc_hd__inv_1
X12_inv22 x12_n21 0 0 VPWR VPWR x12_n22 sky130_fd_sc_hd__inv_1
X12_inv23 x12_n22 0 0 VPWR VPWR x12_n23 sky130_fd_sc_hd__inv_1
X12_inv24 x12_n23 0 0 VPWR VPWR x12_n24 sky130_fd_sc_hd__inv_1
X12_inv25 x12_n24 0 0 VPWR VPWR x12_n25 sky130_fd_sc_hd__inv_1
X12_inv26 x12_n25 0 0 VPWR VPWR x12_n26 sky130_fd_sc_hd__inv_1
X12_inv27 x12_n26 0 0 VPWR VPWR x12_n27 sky130_fd_sc_hd__inv_1
X12_inv28 x12_n27 0 0 VPWR VPWR x12_n28 sky130_fd_sc_hd__inv_1
X12_inv29 x12_n28 0 0 VPWR VPWR x12_n29 sky130_fd_sc_hd__inv_1
X12_inv30 x12_n29 0 0 VPWR VPWR x12_n30 sky130_fd_sc_hd__inv_1
X12_buf x12_n15 0 0 VPWR VPWR x12_out sky130_fd_sc_hd__buf_1
* --- RO 13 ---
X13_nand EN x13_n30 0 0 VPWR VPWR x13_n0 sky130_fd_sc_hd__nand2_1
X13_inv1 x13_n0 0 0 VPWR VPWR x13_n1 sky130_fd_sc_hd__inv_1
X13_inv2 x13_n1 0 0 VPWR VPWR x13_n2 sky130_fd_sc_hd__inv_1
X13_inv3 x13_n2 0 0 VPWR VPWR x13_n3 sky130_fd_sc_hd__inv_1
X13_inv4 x13_n3 0 0 VPWR VPWR x13_n4 sky130_fd_sc_hd__inv_1
X13_inv5 x13_n4 0 0 VPWR VPWR x13_n5 sky130_fd_sc_hd__inv_1
X13_inv6 x13_n5 0 0 VPWR VPWR x13_n6 sky130_fd_sc_hd__inv_1
X13_inv7 x13_n6 0 0 VPWR VPWR x13_n7 sky130_fd_sc_hd__inv_1
X13_inv8 x13_n7 0 0 VPWR VPWR x13_n8 sky130_fd_sc_hd__inv_1
X13_inv9 x13_n8 0 0 VPWR VPWR x13_n9 sky130_fd_sc_hd__inv_1
X13_inv10 x13_n9 0 0 VPWR VPWR x13_n10 sky130_fd_sc_hd__inv_1
X13_inv11 x13_n10 0 0 VPWR VPWR x13_n11 sky130_fd_sc_hd__inv_1
X13_inv12 x13_n11 0 0 VPWR VPWR x13_n12 sky130_fd_sc_hd__inv_1
X13_inv13 x13_n12 0 0 VPWR VPWR x13_n13 sky130_fd_sc_hd__inv_1
X13_inv14 x13_n13 0 0 VPWR VPWR x13_n14 sky130_fd_sc_hd__inv_1
X13_inv15 x13_n14 0 0 VPWR VPWR x13_n15 sky130_fd_sc_hd__inv_1
X13_inv16 x13_n15 0 0 VPWR VPWR x13_n16 sky130_fd_sc_hd__inv_1
X13_inv17 x13_n16 0 0 VPWR VPWR x13_n17 sky130_fd_sc_hd__inv_1
X13_inv18 x13_n17 0 0 VPWR VPWR x13_n18 sky130_fd_sc_hd__inv_1
X13_inv19 x13_n18 0 0 VPWR VPWR x13_n19 sky130_fd_sc_hd__inv_1
X13_inv20 x13_n19 0 0 VPWR VPWR x13_n20 sky130_fd_sc_hd__inv_1
X13_inv21 x13_n20 0 0 VPWR VPWR x13_n21 sky130_fd_sc_hd__inv_1
X13_inv22 x13_n21 0 0 VPWR VPWR x13_n22 sky130_fd_sc_hd__inv_1
X13_inv23 x13_n22 0 0 VPWR VPWR x13_n23 sky130_fd_sc_hd__inv_1
X13_inv24 x13_n23 0 0 VPWR VPWR x13_n24 sky130_fd_sc_hd__inv_1
X13_inv25 x13_n24 0 0 VPWR VPWR x13_n25 sky130_fd_sc_hd__inv_1
X13_inv26 x13_n25 0 0 VPWR VPWR x13_n26 sky130_fd_sc_hd__inv_1
X13_inv27 x13_n26 0 0 VPWR VPWR x13_n27 sky130_fd_sc_hd__inv_1
X13_inv28 x13_n27 0 0 VPWR VPWR x13_n28 sky130_fd_sc_hd__inv_1
X13_inv29 x13_n28 0 0 VPWR VPWR x13_n29 sky130_fd_sc_hd__inv_1
X13_inv30 x13_n29 0 0 VPWR VPWR x13_n30 sky130_fd_sc_hd__inv_1
X13_buf x13_n15 0 0 VPWR VPWR x13_out sky130_fd_sc_hd__buf_1
* --- RO 14 ---
X14_nand EN x14_n30 0 0 VPWR VPWR x14_n0 sky130_fd_sc_hd__nand2_1
X14_inv1 x14_n0 0 0 VPWR VPWR x14_n1 sky130_fd_sc_hd__inv_1
X14_inv2 x14_n1 0 0 VPWR VPWR x14_n2 sky130_fd_sc_hd__inv_1
X14_inv3 x14_n2 0 0 VPWR VPWR x14_n3 sky130_fd_sc_hd__inv_1
X14_inv4 x14_n3 0 0 VPWR VPWR x14_n4 sky130_fd_sc_hd__inv_1
X14_inv5 x14_n4 0 0 VPWR VPWR x14_n5 sky130_fd_sc_hd__inv_1
X14_inv6 x14_n5 0 0 VPWR VPWR x14_n6 sky130_fd_sc_hd__inv_1
X14_inv7 x14_n6 0 0 VPWR VPWR x14_n7 sky130_fd_sc_hd__inv_1
X14_inv8 x14_n7 0 0 VPWR VPWR x14_n8 sky130_fd_sc_hd__inv_1
X14_inv9 x14_n8 0 0 VPWR VPWR x14_n9 sky130_fd_sc_hd__inv_1
X14_inv10 x14_n9 0 0 VPWR VPWR x14_n10 sky130_fd_sc_hd__inv_1
X14_inv11 x14_n10 0 0 VPWR VPWR x14_n11 sky130_fd_sc_hd__inv_1
X14_inv12 x14_n11 0 0 VPWR VPWR x14_n12 sky130_fd_sc_hd__inv_1
X14_inv13 x14_n12 0 0 VPWR VPWR x14_n13 sky130_fd_sc_hd__inv_1
X14_inv14 x14_n13 0 0 VPWR VPWR x14_n14 sky130_fd_sc_hd__inv_1
X14_inv15 x14_n14 0 0 VPWR VPWR x14_n15 sky130_fd_sc_hd__inv_1
X14_inv16 x14_n15 0 0 VPWR VPWR x14_n16 sky130_fd_sc_hd__inv_1
X14_inv17 x14_n16 0 0 VPWR VPWR x14_n17 sky130_fd_sc_hd__inv_1
X14_inv18 x14_n17 0 0 VPWR VPWR x14_n18 sky130_fd_sc_hd__inv_1
X14_inv19 x14_n18 0 0 VPWR VPWR x14_n19 sky130_fd_sc_hd__inv_1
X14_inv20 x14_n19 0 0 VPWR VPWR x14_n20 sky130_fd_sc_hd__inv_1
X14_inv21 x14_n20 0 0 VPWR VPWR x14_n21 sky130_fd_sc_hd__inv_1
X14_inv22 x14_n21 0 0 VPWR VPWR x14_n22 sky130_fd_sc_hd__inv_1
X14_inv23 x14_n22 0 0 VPWR VPWR x14_n23 sky130_fd_sc_hd__inv_1
X14_inv24 x14_n23 0 0 VPWR VPWR x14_n24 sky130_fd_sc_hd__inv_1
X14_inv25 x14_n24 0 0 VPWR VPWR x14_n25 sky130_fd_sc_hd__inv_1
X14_inv26 x14_n25 0 0 VPWR VPWR x14_n26 sky130_fd_sc_hd__inv_1
X14_inv27 x14_n26 0 0 VPWR VPWR x14_n27 sky130_fd_sc_hd__inv_1
X14_inv28 x14_n27 0 0 VPWR VPWR x14_n28 sky130_fd_sc_hd__inv_1
X14_inv29 x14_n28 0 0 VPWR VPWR x14_n29 sky130_fd_sc_hd__inv_1
X14_inv30 x14_n29 0 0 VPWR VPWR x14_n30 sky130_fd_sc_hd__inv_1
X14_buf x14_n15 0 0 VPWR VPWR x14_out sky130_fd_sc_hd__buf_1
* --- RO 15 ---
X15_nand EN x15_n30 0 0 VPWR VPWR x15_n0 sky130_fd_sc_hd__nand2_1
X15_inv1 x15_n0 0 0 VPWR VPWR x15_n1 sky130_fd_sc_hd__inv_1
X15_inv2 x15_n1 0 0 VPWR VPWR x15_n2 sky130_fd_sc_hd__inv_1
X15_inv3 x15_n2 0 0 VPWR VPWR x15_n3 sky130_fd_sc_hd__inv_1
X15_inv4 x15_n3 0 0 VPWR VPWR x15_n4 sky130_fd_sc_hd__inv_1
X15_inv5 x15_n4 0 0 VPWR VPWR x15_n5 sky130_fd_sc_hd__inv_1
X15_inv6 x15_n5 0 0 VPWR VPWR x15_n6 sky130_fd_sc_hd__inv_1
X15_inv7 x15_n6 0 0 VPWR VPWR x15_n7 sky130_fd_sc_hd__inv_1
X15_inv8 x15_n7 0 0 VPWR VPWR x15_n8 sky130_fd_sc_hd__inv_1
X15_inv9 x15_n8 0 0 VPWR VPWR x15_n9 sky130_fd_sc_hd__inv_1
X15_inv10 x15_n9 0 0 VPWR VPWR x15_n10 sky130_fd_sc_hd__inv_1
X15_inv11 x15_n10 0 0 VPWR VPWR x15_n11 sky130_fd_sc_hd__inv_1
X15_inv12 x15_n11 0 0 VPWR VPWR x15_n12 sky130_fd_sc_hd__inv_1
X15_inv13 x15_n12 0 0 VPWR VPWR x15_n13 sky130_fd_sc_hd__inv_1
X15_inv14 x15_n13 0 0 VPWR VPWR x15_n14 sky130_fd_sc_hd__inv_1
X15_inv15 x15_n14 0 0 VPWR VPWR x15_n15 sky130_fd_sc_hd__inv_1
X15_inv16 x15_n15 0 0 VPWR VPWR x15_n16 sky130_fd_sc_hd__inv_1
X15_inv17 x15_n16 0 0 VPWR VPWR x15_n17 sky130_fd_sc_hd__inv_1
X15_inv18 x15_n17 0 0 VPWR VPWR x15_n18 sky130_fd_sc_hd__inv_1
X15_inv19 x15_n18 0 0 VPWR VPWR x15_n19 sky130_fd_sc_hd__inv_1
X15_inv20 x15_n19 0 0 VPWR VPWR x15_n20 sky130_fd_sc_hd__inv_1
X15_inv21 x15_n20 0 0 VPWR VPWR x15_n21 sky130_fd_sc_hd__inv_1
X15_inv22 x15_n21 0 0 VPWR VPWR x15_n22 sky130_fd_sc_hd__inv_1
X15_inv23 x15_n22 0 0 VPWR VPWR x15_n23 sky130_fd_sc_hd__inv_1
X15_inv24 x15_n23 0 0 VPWR VPWR x15_n24 sky130_fd_sc_hd__inv_1
X15_inv25 x15_n24 0 0 VPWR VPWR x15_n25 sky130_fd_sc_hd__inv_1
X15_inv26 x15_n25 0 0 VPWR VPWR x15_n26 sky130_fd_sc_hd__inv_1
X15_inv27 x15_n26 0 0 VPWR VPWR x15_n27 sky130_fd_sc_hd__inv_1
X15_inv28 x15_n27 0 0 VPWR VPWR x15_n28 sky130_fd_sc_hd__inv_1
X15_inv29 x15_n28 0 0 VPWR VPWR x15_n29 sky130_fd_sc_hd__inv_1
X15_inv30 x15_n29 0 0 VPWR VPWR x15_n30 sky130_fd_sc_hd__inv_1
X15_buf x15_n15 0 0 VPWR VPWR x15_out sky130_fd_sc_hd__buf_1

.save v(x0_out) v(x1_out) v(x2_out) v(x3_out) v(x4_out) v(x5_out) v(x6_out) v(x7_out) v(x8_out) v(x9_out) v(x10_out) v(x11_out) v(x12_out) v(x13_out) v(x14_out) v(x15_out)
.tran 5p 80n
.control
run
meas tran tp0 TRIG v(x0_out) VAL=0.9 RISE=5 TARG v(x0_out) VAL=0.9 RISE=25
meas tran tp1 TRIG v(x1_out) VAL=0.9 RISE=5 TARG v(x1_out) VAL=0.9 RISE=25
meas tran tp2 TRIG v(x2_out) VAL=0.9 RISE=5 TARG v(x2_out) VAL=0.9 RISE=25
meas tran tp3 TRIG v(x3_out) VAL=0.9 RISE=5 TARG v(x3_out) VAL=0.9 RISE=25
meas tran tp4 TRIG v(x4_out) VAL=0.9 RISE=5 TARG v(x4_out) VAL=0.9 RISE=25
meas tran tp5 TRIG v(x5_out) VAL=0.9 RISE=5 TARG v(x5_out) VAL=0.9 RISE=25
meas tran tp6 TRIG v(x6_out) VAL=0.9 RISE=5 TARG v(x6_out) VAL=0.9 RISE=25
meas tran tp7 TRIG v(x7_out) VAL=0.9 RISE=5 TARG v(x7_out) VAL=0.9 RISE=25
meas tran tp8 TRIG v(x8_out) VAL=0.9 RISE=5 TARG v(x8_out) VAL=0.9 RISE=25
meas tran tp9 TRIG v(x9_out) VAL=0.9 RISE=5 TARG v(x9_out) VAL=0.9 RISE=25
meas tran tp10 TRIG v(x10_out) VAL=0.9 RISE=5 TARG v(x10_out) VAL=0.9 RISE=25
meas tran tp11 TRIG v(x11_out) VAL=0.9 RISE=5 TARG v(x11_out) VAL=0.9 RISE=25
meas tran tp12 TRIG v(x12_out) VAL=0.9 RISE=5 TARG v(x12_out) VAL=0.9 RISE=25
meas tran tp13 TRIG v(x13_out) VAL=0.9 RISE=5 TARG v(x13_out) VAL=0.9 RISE=25
meas tran tp14 TRIG v(x14_out) VAL=0.9 RISE=5 TARG v(x14_out) VAL=0.9 RISE=25
meas tran tp15 TRIG v(x15_out) VAL=0.9 RISE=5 TARG v(x15_out) VAL=0.9 RISE=25
let f0 = 20 / tp0
let f1 = 20 / tp1
let f2 = 20 / tp2
let f3 = 20 / tp3
let f4 = 20 / tp4
let f5 = 20 / tp5
let f6 = 20 / tp6
let f7 = 20 / tp7
let f8 = 20 / tp8
let f9 = 20 / tp9
let f10 = 20 / tp10
let f11 = 20 / tp11
let f12 = 20 / tp12
let f13 = 20 / tp13
let f14 = 20 / tp14
let f15 = 20 / tp15
print f0
print f1
print f2
print f3
print f4
print f5
print f6
print f7
print f8
print f9
print f10
print f11
print f12
print f13
print f14
print f15
.endc
.end
