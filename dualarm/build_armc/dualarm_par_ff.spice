* Pre-silicon lumped-C go/no-go: PARASITIC (nom SPEF), ff -40C 1.95V
* auto-generated by gen_dualarm_decks.py -- 16 Arm A ROs, enable-started
.lib "/tmp/pdk/sky130A/libs.tech/ngspice/sky130.lib.spice" ff
.include "/tmp/pdk/sky130A/libs.ref/sky130_fd_sc_hd/spice/sky130_fd_sc_hd.spice"
.temp -40
.param SUPPLY=1.95
Vdd VPWR 0 {SUPPLY}
Ven EN 0 PULSE(0 1.95 2n 50p 50p 1 2)

* --- RO 0 ---
X0_nand EN x0_n30 0 0 VPWR VPWR x0_n0 sky130_fd_sc_hd__nand2_1
X0_inv1 x0_n0 0 0 VPWR VPWR x0_n1 sky130_fd_sc_hd__inv_1
X0_inv2 x0_n1 0 0 VPWR VPWR x0_n2 sky130_fd_sc_hd__inv_1
X0_inv3 x0_n2 0 0 VPWR VPWR x0_n3 sky130_fd_sc_hd__inv_1
X0_inv4 x0_n3 0 0 VPWR VPWR x0_n4 sky130_fd_sc_hd__inv_1
X0_inv5 x0_n4 0 0 VPWR VPWR x0_n5 sky130_fd_sc_hd__inv_1
X0_inv6 x0_n5 0 0 VPWR VPWR x0_n6 sky130_fd_sc_hd__inv_1
X0_inv7 x0_n6 0 0 VPWR VPWR x0_n7 sky130_fd_sc_hd__inv_1
X0_inv8 x0_n7 0 0 VPWR VPWR x0_n8 sky130_fd_sc_hd__inv_1
X0_inv9 x0_n8 0 0 VPWR VPWR x0_n9 sky130_fd_sc_hd__inv_1
X0_inv10 x0_n9 0 0 VPWR VPWR x0_n10 sky130_fd_sc_hd__inv_1
X0_inv11 x0_n10 0 0 VPWR VPWR x0_n11 sky130_fd_sc_hd__inv_1
X0_inv12 x0_n11 0 0 VPWR VPWR x0_n12 sky130_fd_sc_hd__inv_1
X0_inv13 x0_n12 0 0 VPWR VPWR x0_n13 sky130_fd_sc_hd__inv_1
X0_inv14 x0_n13 0 0 VPWR VPWR x0_n14 sky130_fd_sc_hd__inv_1
X0_inv15 x0_n14 0 0 VPWR VPWR x0_n15 sky130_fd_sc_hd__inv_1
X0_inv16 x0_n15 0 0 VPWR VPWR x0_n16 sky130_fd_sc_hd__inv_1
X0_inv17 x0_n16 0 0 VPWR VPWR x0_n17 sky130_fd_sc_hd__inv_1
X0_inv18 x0_n17 0 0 VPWR VPWR x0_n18 sky130_fd_sc_hd__inv_1
X0_inv19 x0_n18 0 0 VPWR VPWR x0_n19 sky130_fd_sc_hd__inv_1
X0_inv20 x0_n19 0 0 VPWR VPWR x0_n20 sky130_fd_sc_hd__inv_1
X0_inv21 x0_n20 0 0 VPWR VPWR x0_n21 sky130_fd_sc_hd__inv_1
X0_inv22 x0_n21 0 0 VPWR VPWR x0_n22 sky130_fd_sc_hd__inv_1
X0_inv23 x0_n22 0 0 VPWR VPWR x0_n23 sky130_fd_sc_hd__inv_1
X0_inv24 x0_n23 0 0 VPWR VPWR x0_n24 sky130_fd_sc_hd__inv_1
X0_inv25 x0_n24 0 0 VPWR VPWR x0_n25 sky130_fd_sc_hd__inv_1
X0_inv26 x0_n25 0 0 VPWR VPWR x0_n26 sky130_fd_sc_hd__inv_1
X0_inv27 x0_n26 0 0 VPWR VPWR x0_n27 sky130_fd_sc_hd__inv_1
X0_inv28 x0_n27 0 0 VPWR VPWR x0_n28 sky130_fd_sc_hd__inv_1
X0_inv29 x0_n28 0 0 VPWR VPWR x0_n29 sky130_fd_sc_hd__inv_1
X0_inv30 x0_n29 0 0 VPWR VPWR x0_n30 sky130_fd_sc_hd__inv_1
X0_buf x0_n15 0 0 VPWR VPWR x0_out sky130_fd_sc_hd__buf_1
C0_n0 x0_n0 0 3.613360e-16
C0_n1 x0_n1 0 1.581620e-16
C0_n2 x0_n2 0 3.838830e-16
C0_n3 x0_n3 0 1.074020e-15
C0_n4 x0_n4 0 7.514990e-16
C0_n5 x0_n5 0 4.572160e-16
C0_n6 x0_n6 0 3.183810e-16
C0_n7 x0_n7 0 3.114440e-16
C0_n8 x0_n8 0 3.404860e-16
C0_n9 x0_n9 0 5.371450e-16
C0_n10 x0_n10 0 3.122060e-16
C0_n11 x0_n11 0 7.970930e-16
C0_n12 x0_n12 0 6.606540e-16
C0_n13 x0_n13 0 3.360860e-16
C0_n14 x0_n14 0 6.171210e-16
C0_n15 x0_n15 0 8.966660e-16
C0_n16 x0_n16 0 8.839110e-16
C0_n17 x0_n17 0 6.668680e-16
C0_n18 x0_n18 0 3.971060e-16
C0_n19 x0_n19 0 3.815760e-16
C0_n20 x0_n20 0 4.406580e-16
C0_n21 x0_n21 0 7.791630e-16
C0_n22 x0_n22 0 7.314160e-16
C0_n23 x0_n23 0 8.293010e-16
C0_n24 x0_n24 0 1.083880e-16
C0_n25 x0_n25 0 1.070650e-16
C0_n26 x0_n26 0 1.201080e-16
C0_n27 x0_n27 0 4.921860e-16
C0_n28 x0_n28 0 1.556920e-16
C0_n29 x0_n29 0 4.171700e-16
C0_n30 x0_n30 0 1.072760e-16
C0_out x0_out 0 7.503840e-15
* --- RO 1 ---
X1_nand EN x1_n30 0 0 VPWR VPWR x1_n0 sky130_fd_sc_hd__nand2_1
X1_inv1 x1_n0 0 0 VPWR VPWR x1_n1 sky130_fd_sc_hd__inv_1
X1_inv2 x1_n1 0 0 VPWR VPWR x1_n2 sky130_fd_sc_hd__inv_1
X1_inv3 x1_n2 0 0 VPWR VPWR x1_n3 sky130_fd_sc_hd__inv_1
X1_inv4 x1_n3 0 0 VPWR VPWR x1_n4 sky130_fd_sc_hd__inv_1
X1_inv5 x1_n4 0 0 VPWR VPWR x1_n5 sky130_fd_sc_hd__inv_1
X1_inv6 x1_n5 0 0 VPWR VPWR x1_n6 sky130_fd_sc_hd__inv_1
X1_inv7 x1_n6 0 0 VPWR VPWR x1_n7 sky130_fd_sc_hd__inv_1
X1_inv8 x1_n7 0 0 VPWR VPWR x1_n8 sky130_fd_sc_hd__inv_1
X1_inv9 x1_n8 0 0 VPWR VPWR x1_n9 sky130_fd_sc_hd__inv_1
X1_inv10 x1_n9 0 0 VPWR VPWR x1_n10 sky130_fd_sc_hd__inv_1
X1_inv11 x1_n10 0 0 VPWR VPWR x1_n11 sky130_fd_sc_hd__inv_1
X1_inv12 x1_n11 0 0 VPWR VPWR x1_n12 sky130_fd_sc_hd__inv_1
X1_inv13 x1_n12 0 0 VPWR VPWR x1_n13 sky130_fd_sc_hd__inv_1
X1_inv14 x1_n13 0 0 VPWR VPWR x1_n14 sky130_fd_sc_hd__inv_1
X1_inv15 x1_n14 0 0 VPWR VPWR x1_n15 sky130_fd_sc_hd__inv_1
X1_inv16 x1_n15 0 0 VPWR VPWR x1_n16 sky130_fd_sc_hd__inv_1
X1_inv17 x1_n16 0 0 VPWR VPWR x1_n17 sky130_fd_sc_hd__inv_1
X1_inv18 x1_n17 0 0 VPWR VPWR x1_n18 sky130_fd_sc_hd__inv_1
X1_inv19 x1_n18 0 0 VPWR VPWR x1_n19 sky130_fd_sc_hd__inv_1
X1_inv20 x1_n19 0 0 VPWR VPWR x1_n20 sky130_fd_sc_hd__inv_1
X1_inv21 x1_n20 0 0 VPWR VPWR x1_n21 sky130_fd_sc_hd__inv_1
X1_inv22 x1_n21 0 0 VPWR VPWR x1_n22 sky130_fd_sc_hd__inv_1
X1_inv23 x1_n22 0 0 VPWR VPWR x1_n23 sky130_fd_sc_hd__inv_1
X1_inv24 x1_n23 0 0 VPWR VPWR x1_n24 sky130_fd_sc_hd__inv_1
X1_inv25 x1_n24 0 0 VPWR VPWR x1_n25 sky130_fd_sc_hd__inv_1
X1_inv26 x1_n25 0 0 VPWR VPWR x1_n26 sky130_fd_sc_hd__inv_1
X1_inv27 x1_n26 0 0 VPWR VPWR x1_n27 sky130_fd_sc_hd__inv_1
X1_inv28 x1_n27 0 0 VPWR VPWR x1_n28 sky130_fd_sc_hd__inv_1
X1_inv29 x1_n28 0 0 VPWR VPWR x1_n29 sky130_fd_sc_hd__inv_1
X1_inv30 x1_n29 0 0 VPWR VPWR x1_n30 sky130_fd_sc_hd__inv_1
X1_buf x1_n15 0 0 VPWR VPWR x1_out sky130_fd_sc_hd__buf_1
C1_n0 x1_n0 0 2.379430e-16
C1_n1 x1_n1 0 1.647750e-16
C1_n2 x1_n2 0 6.413100e-16
C1_n3 x1_n3 0 6.965740e-16
C1_n4 x1_n4 0 2.125310e-16
C1_n5 x1_n5 0 4.457740e-16
C1_n6 x1_n6 0 3.525900e-16
C1_n7 x1_n7 0 4.042640e-16
C1_n8 x1_n8 0 3.515760e-16
C1_n9 x1_n9 0 5.335780e-16
C1_n10 x1_n10 0 5.236190e-16
C1_n11 x1_n11 0 8.124370e-16
C1_n12 x1_n12 0 5.297400e-16
C1_n13 x1_n13 0 5.570960e-16
C1_n14 x1_n14 0 3.711560e-16
C1_n15 x1_n15 0 1.545600e-15
C1_n16 x1_n16 0 6.523330e-16
C1_n17 x1_n17 0 1.240500e-15
C1_n18 x1_n18 0 2.045530e-16
C1_n19 x1_n19 0 1.556730e-16
C1_n20 x1_n20 0 1.067930e-16
C1_n21 x1_n21 0 1.067930e-16
C1_n22 x1_n22 0 3.649760e-16
C1_n23 x1_n23 0 2.125310e-16
C1_n24 x1_n24 0 6.600010e-16
C1_n25 x1_n25 0 6.293220e-16
C1_n26 x1_n26 0 1.261260e-16
C1_n27 x1_n27 0 6.511890e-16
C1_n28 x1_n28 0 4.150430e-16
C1_n29 x1_n29 0 7.755610e-16
C1_n30 x1_n30 0 1.610100e-15
C1_out x1_out 0 1.612980e-15
* --- RO 2 ---
X2_nand EN x2_n30 0 0 VPWR VPWR x2_n0 sky130_fd_sc_hd__nand2_1
X2_inv1 x2_n0 0 0 VPWR VPWR x2_n1 sky130_fd_sc_hd__inv_1
X2_inv2 x2_n1 0 0 VPWR VPWR x2_n2 sky130_fd_sc_hd__inv_1
X2_inv3 x2_n2 0 0 VPWR VPWR x2_n3 sky130_fd_sc_hd__inv_1
X2_inv4 x2_n3 0 0 VPWR VPWR x2_n4 sky130_fd_sc_hd__inv_1
X2_inv5 x2_n4 0 0 VPWR VPWR x2_n5 sky130_fd_sc_hd__inv_1
X2_inv6 x2_n5 0 0 VPWR VPWR x2_n6 sky130_fd_sc_hd__inv_1
X2_inv7 x2_n6 0 0 VPWR VPWR x2_n7 sky130_fd_sc_hd__inv_1
X2_inv8 x2_n7 0 0 VPWR VPWR x2_n8 sky130_fd_sc_hd__inv_1
X2_inv9 x2_n8 0 0 VPWR VPWR x2_n9 sky130_fd_sc_hd__inv_1
X2_inv10 x2_n9 0 0 VPWR VPWR x2_n10 sky130_fd_sc_hd__inv_1
X2_inv11 x2_n10 0 0 VPWR VPWR x2_n11 sky130_fd_sc_hd__inv_1
X2_inv12 x2_n11 0 0 VPWR VPWR x2_n12 sky130_fd_sc_hd__inv_1
X2_inv13 x2_n12 0 0 VPWR VPWR x2_n13 sky130_fd_sc_hd__inv_1
X2_inv14 x2_n13 0 0 VPWR VPWR x2_n14 sky130_fd_sc_hd__inv_1
X2_inv15 x2_n14 0 0 VPWR VPWR x2_n15 sky130_fd_sc_hd__inv_1
X2_inv16 x2_n15 0 0 VPWR VPWR x2_n16 sky130_fd_sc_hd__inv_1
X2_inv17 x2_n16 0 0 VPWR VPWR x2_n17 sky130_fd_sc_hd__inv_1
X2_inv18 x2_n17 0 0 VPWR VPWR x2_n18 sky130_fd_sc_hd__inv_1
X2_inv19 x2_n18 0 0 VPWR VPWR x2_n19 sky130_fd_sc_hd__inv_1
X2_inv20 x2_n19 0 0 VPWR VPWR x2_n20 sky130_fd_sc_hd__inv_1
X2_inv21 x2_n20 0 0 VPWR VPWR x2_n21 sky130_fd_sc_hd__inv_1
X2_inv22 x2_n21 0 0 VPWR VPWR x2_n22 sky130_fd_sc_hd__inv_1
X2_inv23 x2_n22 0 0 VPWR VPWR x2_n23 sky130_fd_sc_hd__inv_1
X2_inv24 x2_n23 0 0 VPWR VPWR x2_n24 sky130_fd_sc_hd__inv_1
X2_inv25 x2_n24 0 0 VPWR VPWR x2_n25 sky130_fd_sc_hd__inv_1
X2_inv26 x2_n25 0 0 VPWR VPWR x2_n26 sky130_fd_sc_hd__inv_1
X2_inv27 x2_n26 0 0 VPWR VPWR x2_n27 sky130_fd_sc_hd__inv_1
X2_inv28 x2_n27 0 0 VPWR VPWR x2_n28 sky130_fd_sc_hd__inv_1
X2_inv29 x2_n28 0 0 VPWR VPWR x2_n29 sky130_fd_sc_hd__inv_1
X2_inv30 x2_n29 0 0 VPWR VPWR x2_n30 sky130_fd_sc_hd__inv_1
X2_buf x2_n15 0 0 VPWR VPWR x2_out sky130_fd_sc_hd__buf_1
C2_n0 x2_n0 0 2.644490e-16
C2_n1 x2_n1 0 6.285740e-16
C2_n2 x2_n2 0 7.486820e-16
C2_n3 x2_n3 0 3.051040e-16
C2_n4 x2_n4 0 3.717370e-16
C2_n5 x2_n5 0 5.482750e-16
C2_n6 x2_n6 0 5.930790e-16
C2_n7 x2_n7 0 1.705450e-16
C2_n8 x2_n8 0 8.493840e-16
C2_n9 x2_n9 0 6.109750e-16
C2_n10 x2_n10 0 1.603520e-16
C2_n11 x2_n11 0 4.422100e-16
C2_n12 x2_n12 0 1.070650e-16
C2_n13 x2_n13 0 6.675040e-16
C2_n14 x2_n14 0 3.610920e-16
C2_n15 x2_n15 0 9.982380e-16
C2_n16 x2_n16 0 5.780600e-16
C2_n17 x2_n17 0 1.344320e-16
C2_n18 x2_n18 0 1.187610e-16
C2_n19 x2_n19 0 7.095320e-16
C2_n20 x2_n20 0 2.294500e-16
C2_n21 x2_n21 0 6.136440e-16
C2_n22 x2_n22 0 5.929890e-16
C2_n23 x2_n23 0 3.729320e-16
C2_n24 x2_n24 0 4.534520e-16
C2_n25 x2_n25 0 8.965680e-16
C2_n26 x2_n26 0 1.164520e-15
C2_n27 x2_n27 0 6.859360e-16
C2_n28 x2_n28 0 5.110230e-16
C2_n29 x2_n29 0 2.852590e-16
C2_n30 x2_n30 0 3.785710e-16
C2_out x2_out 0 1.874470e-15
* --- RO 3 ---
X3_nand EN x3_n30 0 0 VPWR VPWR x3_n0 sky130_fd_sc_hd__nand2_1
X3_inv1 x3_n0 0 0 VPWR VPWR x3_n1 sky130_fd_sc_hd__inv_1
X3_inv2 x3_n1 0 0 VPWR VPWR x3_n2 sky130_fd_sc_hd__inv_1
X3_inv3 x3_n2 0 0 VPWR VPWR x3_n3 sky130_fd_sc_hd__inv_1
X3_inv4 x3_n3 0 0 VPWR VPWR x3_n4 sky130_fd_sc_hd__inv_1
X3_inv5 x3_n4 0 0 VPWR VPWR x3_n5 sky130_fd_sc_hd__inv_1
X3_inv6 x3_n5 0 0 VPWR VPWR x3_n6 sky130_fd_sc_hd__inv_1
X3_inv7 x3_n6 0 0 VPWR VPWR x3_n7 sky130_fd_sc_hd__inv_1
X3_inv8 x3_n7 0 0 VPWR VPWR x3_n8 sky130_fd_sc_hd__inv_1
X3_inv9 x3_n8 0 0 VPWR VPWR x3_n9 sky130_fd_sc_hd__inv_1
X3_inv10 x3_n9 0 0 VPWR VPWR x3_n10 sky130_fd_sc_hd__inv_1
X3_inv11 x3_n10 0 0 VPWR VPWR x3_n11 sky130_fd_sc_hd__inv_1
X3_inv12 x3_n11 0 0 VPWR VPWR x3_n12 sky130_fd_sc_hd__inv_1
X3_inv13 x3_n12 0 0 VPWR VPWR x3_n13 sky130_fd_sc_hd__inv_1
X3_inv14 x3_n13 0 0 VPWR VPWR x3_n14 sky130_fd_sc_hd__inv_1
X3_inv15 x3_n14 0 0 VPWR VPWR x3_n15 sky130_fd_sc_hd__inv_1
X3_inv16 x3_n15 0 0 VPWR VPWR x3_n16 sky130_fd_sc_hd__inv_1
X3_inv17 x3_n16 0 0 VPWR VPWR x3_n17 sky130_fd_sc_hd__inv_1
X3_inv18 x3_n17 0 0 VPWR VPWR x3_n18 sky130_fd_sc_hd__inv_1
X3_inv19 x3_n18 0 0 VPWR VPWR x3_n19 sky130_fd_sc_hd__inv_1
X3_inv20 x3_n19 0 0 VPWR VPWR x3_n20 sky130_fd_sc_hd__inv_1
X3_inv21 x3_n20 0 0 VPWR VPWR x3_n21 sky130_fd_sc_hd__inv_1
X3_inv22 x3_n21 0 0 VPWR VPWR x3_n22 sky130_fd_sc_hd__inv_1
X3_inv23 x3_n22 0 0 VPWR VPWR x3_n23 sky130_fd_sc_hd__inv_1
X3_inv24 x3_n23 0 0 VPWR VPWR x3_n24 sky130_fd_sc_hd__inv_1
X3_inv25 x3_n24 0 0 VPWR VPWR x3_n25 sky130_fd_sc_hd__inv_1
X3_inv26 x3_n25 0 0 VPWR VPWR x3_n26 sky130_fd_sc_hd__inv_1
X3_inv27 x3_n26 0 0 VPWR VPWR x3_n27 sky130_fd_sc_hd__inv_1
X3_inv28 x3_n27 0 0 VPWR VPWR x3_n28 sky130_fd_sc_hd__inv_1
X3_inv29 x3_n28 0 0 VPWR VPWR x3_n29 sky130_fd_sc_hd__inv_1
X3_inv30 x3_n29 0 0 VPWR VPWR x3_n30 sky130_fd_sc_hd__inv_1
X3_buf x3_n15 0 0 VPWR VPWR x3_out sky130_fd_sc_hd__buf_1
C3_n0 x3_n0 0 2.064710e-16
C3_n1 x3_n1 0 1.887930e-16
C3_n2 x3_n2 0 5.328560e-16
C3_n3 x3_n3 0 3.978080e-16
C3_n4 x3_n4 0 9.997970e-16
C3_n5 x3_n5 0 1.872510e-16
C3_n6 x3_n6 0 1.045570e-15
C3_n7 x3_n7 0 1.206590e-15
C3_n8 x3_n8 0 7.863610e-16
C3_n9 x3_n9 0 8.717760e-16
C3_n10 x3_n10 0 5.007240e-16
C3_n11 x3_n11 0 3.336130e-16
C3_n12 x3_n12 0 4.066190e-16
C3_n13 x3_n13 0 5.956680e-16
C3_n14 x3_n14 0 3.555360e-16
C3_n15 x3_n15 0 9.678670e-16
C3_n16 x3_n16 0 9.318310e-16
C3_n17 x3_n17 0 8.554500e-16
C3_n18 x3_n18 0 5.364200e-16
C3_n19 x3_n19 0 3.623020e-16
C3_n20 x3_n20 0 3.724780e-16
C3_n21 x3_n21 0 3.079530e-16
C3_n22 x3_n22 0 7.891050e-16
C3_n23 x3_n23 0 1.343260e-16
C3_n24 x3_n24 0 5.088620e-16
C3_n25 x3_n25 0 2.886410e-16
C3_n26 x3_n26 0 4.531270e-16
C3_n27 x3_n27 0 3.208420e-16
C3_n28 x3_n28 0 4.615870e-16
C3_n29 x3_n29 0 3.943440e-16
C3_n30 x3_n30 0 8.819690e-17
C3_out x3_out 0 9.248000e-15
* --- RO 4 ---
X4_nand EN x4_n30 0 0 VPWR VPWR x4_n0 sky130_fd_sc_hd__nand2_1
X4_inv1 x4_n0 0 0 VPWR VPWR x4_n1 sky130_fd_sc_hd__inv_1
X4_inv2 x4_n1 0 0 VPWR VPWR x4_n2 sky130_fd_sc_hd__inv_1
X4_inv3 x4_n2 0 0 VPWR VPWR x4_n3 sky130_fd_sc_hd__inv_1
X4_inv4 x4_n3 0 0 VPWR VPWR x4_n4 sky130_fd_sc_hd__inv_1
X4_inv5 x4_n4 0 0 VPWR VPWR x4_n5 sky130_fd_sc_hd__inv_1
X4_inv6 x4_n5 0 0 VPWR VPWR x4_n6 sky130_fd_sc_hd__inv_1
X4_inv7 x4_n6 0 0 VPWR VPWR x4_n7 sky130_fd_sc_hd__inv_1
X4_inv8 x4_n7 0 0 VPWR VPWR x4_n8 sky130_fd_sc_hd__inv_1
X4_inv9 x4_n8 0 0 VPWR VPWR x4_n9 sky130_fd_sc_hd__inv_1
X4_inv10 x4_n9 0 0 VPWR VPWR x4_n10 sky130_fd_sc_hd__inv_1
X4_inv11 x4_n10 0 0 VPWR VPWR x4_n11 sky130_fd_sc_hd__inv_1
X4_inv12 x4_n11 0 0 VPWR VPWR x4_n12 sky130_fd_sc_hd__inv_1
X4_inv13 x4_n12 0 0 VPWR VPWR x4_n13 sky130_fd_sc_hd__inv_1
X4_inv14 x4_n13 0 0 VPWR VPWR x4_n14 sky130_fd_sc_hd__inv_1
X4_inv15 x4_n14 0 0 VPWR VPWR x4_n15 sky130_fd_sc_hd__inv_1
X4_inv16 x4_n15 0 0 VPWR VPWR x4_n16 sky130_fd_sc_hd__inv_1
X4_inv17 x4_n16 0 0 VPWR VPWR x4_n17 sky130_fd_sc_hd__inv_1
X4_inv18 x4_n17 0 0 VPWR VPWR x4_n18 sky130_fd_sc_hd__inv_1
X4_inv19 x4_n18 0 0 VPWR VPWR x4_n19 sky130_fd_sc_hd__inv_1
X4_inv20 x4_n19 0 0 VPWR VPWR x4_n20 sky130_fd_sc_hd__inv_1
X4_inv21 x4_n20 0 0 VPWR VPWR x4_n21 sky130_fd_sc_hd__inv_1
X4_inv22 x4_n21 0 0 VPWR VPWR x4_n22 sky130_fd_sc_hd__inv_1
X4_inv23 x4_n22 0 0 VPWR VPWR x4_n23 sky130_fd_sc_hd__inv_1
X4_inv24 x4_n23 0 0 VPWR VPWR x4_n24 sky130_fd_sc_hd__inv_1
X4_inv25 x4_n24 0 0 VPWR VPWR x4_n25 sky130_fd_sc_hd__inv_1
X4_inv26 x4_n25 0 0 VPWR VPWR x4_n26 sky130_fd_sc_hd__inv_1
X4_inv27 x4_n26 0 0 VPWR VPWR x4_n27 sky130_fd_sc_hd__inv_1
X4_inv28 x4_n27 0 0 VPWR VPWR x4_n28 sky130_fd_sc_hd__inv_1
X4_inv29 x4_n28 0 0 VPWR VPWR x4_n29 sky130_fd_sc_hd__inv_1
X4_inv30 x4_n29 0 0 VPWR VPWR x4_n30 sky130_fd_sc_hd__inv_1
X4_buf x4_n15 0 0 VPWR VPWR x4_out sky130_fd_sc_hd__buf_1
C4_n0 x4_n0 0 3.280240e-16
C4_n1 x4_n1 0 6.764350e-16
C4_n2 x4_n2 0 1.187610e-16
C4_n3 x4_n3 0 5.706330e-16
C4_n4 x4_n4 0 5.817520e-16
C4_n5 x4_n5 0 1.564940e-16
C4_n6 x4_n6 0 3.369030e-16
C4_n7 x4_n7 0 1.067930e-16
C4_n8 x4_n8 0 1.233470e-16
C4_n9 x4_n9 0 1.067930e-16
C4_n10 x4_n10 0 1.562140e-16
C4_n11 x4_n11 0 1.098220e-16
C4_n12 x4_n12 0 1.581620e-16
C4_n13 x4_n13 0 1.233510e-16
C4_n14 x4_n14 0 1.089410e-16
C4_n15 x4_n15 0 6.530040e-16
C4_n16 x4_n16 0 3.467170e-16
C4_n17 x4_n17 0 3.507470e-16
C4_n18 x4_n18 0 3.662880e-16
C4_n19 x4_n19 0 3.128590e-16
C4_n20 x4_n20 0 3.949920e-16
C4_n21 x4_n21 0 3.717600e-16
C4_n22 x4_n22 0 4.280300e-16
C4_n23 x4_n23 0 7.725940e-16
C4_n24 x4_n24 0 1.092810e-16
C4_n25 x4_n25 0 1.388820e-16
C4_n26 x4_n26 0 8.393960e-16
C4_n27 x4_n27 0 4.032890e-16
C4_n28 x4_n28 0 7.086450e-16
C4_n29 x4_n29 0 5.050180e-16
C4_n30 x4_n30 0 4.968290e-16
C4_out x4_out 0 6.027750e-15
* --- RO 5 ---
X5_nand EN x5_n30 0 0 VPWR VPWR x5_n0 sky130_fd_sc_hd__nand2_1
X5_inv1 x5_n0 0 0 VPWR VPWR x5_n1 sky130_fd_sc_hd__inv_1
X5_inv2 x5_n1 0 0 VPWR VPWR x5_n2 sky130_fd_sc_hd__inv_1
X5_inv3 x5_n2 0 0 VPWR VPWR x5_n3 sky130_fd_sc_hd__inv_1
X5_inv4 x5_n3 0 0 VPWR VPWR x5_n4 sky130_fd_sc_hd__inv_1
X5_inv5 x5_n4 0 0 VPWR VPWR x5_n5 sky130_fd_sc_hd__inv_1
X5_inv6 x5_n5 0 0 VPWR VPWR x5_n6 sky130_fd_sc_hd__inv_1
X5_inv7 x5_n6 0 0 VPWR VPWR x5_n7 sky130_fd_sc_hd__inv_1
X5_inv8 x5_n7 0 0 VPWR VPWR x5_n8 sky130_fd_sc_hd__inv_1
X5_inv9 x5_n8 0 0 VPWR VPWR x5_n9 sky130_fd_sc_hd__inv_1
X5_inv10 x5_n9 0 0 VPWR VPWR x5_n10 sky130_fd_sc_hd__inv_1
X5_inv11 x5_n10 0 0 VPWR VPWR x5_n11 sky130_fd_sc_hd__inv_1
X5_inv12 x5_n11 0 0 VPWR VPWR x5_n12 sky130_fd_sc_hd__inv_1
X5_inv13 x5_n12 0 0 VPWR VPWR x5_n13 sky130_fd_sc_hd__inv_1
X5_inv14 x5_n13 0 0 VPWR VPWR x5_n14 sky130_fd_sc_hd__inv_1
X5_inv15 x5_n14 0 0 VPWR VPWR x5_n15 sky130_fd_sc_hd__inv_1
X5_inv16 x5_n15 0 0 VPWR VPWR x5_n16 sky130_fd_sc_hd__inv_1
X5_inv17 x5_n16 0 0 VPWR VPWR x5_n17 sky130_fd_sc_hd__inv_1
X5_inv18 x5_n17 0 0 VPWR VPWR x5_n18 sky130_fd_sc_hd__inv_1
X5_inv19 x5_n18 0 0 VPWR VPWR x5_n19 sky130_fd_sc_hd__inv_1
X5_inv20 x5_n19 0 0 VPWR VPWR x5_n20 sky130_fd_sc_hd__inv_1
X5_inv21 x5_n20 0 0 VPWR VPWR x5_n21 sky130_fd_sc_hd__inv_1
X5_inv22 x5_n21 0 0 VPWR VPWR x5_n22 sky130_fd_sc_hd__inv_1
X5_inv23 x5_n22 0 0 VPWR VPWR x5_n23 sky130_fd_sc_hd__inv_1
X5_inv24 x5_n23 0 0 VPWR VPWR x5_n24 sky130_fd_sc_hd__inv_1
X5_inv25 x5_n24 0 0 VPWR VPWR x5_n25 sky130_fd_sc_hd__inv_1
X5_inv26 x5_n25 0 0 VPWR VPWR x5_n26 sky130_fd_sc_hd__inv_1
X5_inv27 x5_n26 0 0 VPWR VPWR x5_n27 sky130_fd_sc_hd__inv_1
X5_inv28 x5_n27 0 0 VPWR VPWR x5_n28 sky130_fd_sc_hd__inv_1
X5_inv29 x5_n28 0 0 VPWR VPWR x5_n29 sky130_fd_sc_hd__inv_1
X5_inv30 x5_n29 0 0 VPWR VPWR x5_n30 sky130_fd_sc_hd__inv_1
X5_buf x5_n15 0 0 VPWR VPWR x5_out sky130_fd_sc_hd__buf_1
C5_n0 x5_n0 0 2.260610e-16
C5_n1 x5_n1 0 7.173790e-16
C5_n2 x5_n2 0 1.067930e-16
C5_n3 x5_n3 0 1.399380e-16
C5_n4 x5_n4 0 6.693010e-16
C5_n5 x5_n5 0 3.325410e-16
C5_n6 x5_n6 0 3.846030e-16
C5_n7 x5_n7 0 3.385260e-16
C5_n8 x5_n8 0 3.583670e-16
C5_n9 x5_n9 0 3.547220e-16
C5_n10 x5_n10 0 3.258270e-16
C5_n11 x5_n11 0 7.630430e-16
C5_n12 x5_n12 0 1.285880e-16
C5_n13 x5_n13 0 7.625830e-16
C5_n14 x5_n14 0 1.542850e-16
C5_n15 x5_n15 0 1.699560e-15
C5_n16 x5_n16 0 2.968710e-16
C5_n17 x5_n17 0 9.781930e-16
C5_n18 x5_n18 0 1.564940e-16
C5_n19 x5_n19 0 2.281230e-16
C5_n20 x5_n20 0 4.255420e-16
C5_n21 x5_n21 0 1.070810e-16
C5_n22 x5_n22 0 4.059400e-16
C5_n23 x5_n23 0 3.182440e-16
C5_n24 x5_n24 0 4.499960e-16
C5_n25 x5_n25 0 6.239380e-16
C5_n26 x5_n26 0 2.918010e-16
C5_n27 x5_n27 0 3.123380e-16
C5_n28 x5_n28 0 3.600180e-16
C5_n29 x5_n29 0 4.273890e-16
C5_n30 x5_n30 0 6.245560e-16
C5_out x5_out 0 5.736350e-15
* --- RO 6 ---
X6_nand EN x6_n30 0 0 VPWR VPWR x6_n0 sky130_fd_sc_hd__nand2_1
X6_inv1 x6_n0 0 0 VPWR VPWR x6_n1 sky130_fd_sc_hd__inv_1
X6_inv2 x6_n1 0 0 VPWR VPWR x6_n2 sky130_fd_sc_hd__inv_1
X6_inv3 x6_n2 0 0 VPWR VPWR x6_n3 sky130_fd_sc_hd__inv_1
X6_inv4 x6_n3 0 0 VPWR VPWR x6_n4 sky130_fd_sc_hd__inv_1
X6_inv5 x6_n4 0 0 VPWR VPWR x6_n5 sky130_fd_sc_hd__inv_1
X6_inv6 x6_n5 0 0 VPWR VPWR x6_n6 sky130_fd_sc_hd__inv_1
X6_inv7 x6_n6 0 0 VPWR VPWR x6_n7 sky130_fd_sc_hd__inv_1
X6_inv8 x6_n7 0 0 VPWR VPWR x6_n8 sky130_fd_sc_hd__inv_1
X6_inv9 x6_n8 0 0 VPWR VPWR x6_n9 sky130_fd_sc_hd__inv_1
X6_inv10 x6_n9 0 0 VPWR VPWR x6_n10 sky130_fd_sc_hd__inv_1
X6_inv11 x6_n10 0 0 VPWR VPWR x6_n11 sky130_fd_sc_hd__inv_1
X6_inv12 x6_n11 0 0 VPWR VPWR x6_n12 sky130_fd_sc_hd__inv_1
X6_inv13 x6_n12 0 0 VPWR VPWR x6_n13 sky130_fd_sc_hd__inv_1
X6_inv14 x6_n13 0 0 VPWR VPWR x6_n14 sky130_fd_sc_hd__inv_1
X6_inv15 x6_n14 0 0 VPWR VPWR x6_n15 sky130_fd_sc_hd__inv_1
X6_inv16 x6_n15 0 0 VPWR VPWR x6_n16 sky130_fd_sc_hd__inv_1
X6_inv17 x6_n16 0 0 VPWR VPWR x6_n17 sky130_fd_sc_hd__inv_1
X6_inv18 x6_n17 0 0 VPWR VPWR x6_n18 sky130_fd_sc_hd__inv_1
X6_inv19 x6_n18 0 0 VPWR VPWR x6_n19 sky130_fd_sc_hd__inv_1
X6_inv20 x6_n19 0 0 VPWR VPWR x6_n20 sky130_fd_sc_hd__inv_1
X6_inv21 x6_n20 0 0 VPWR VPWR x6_n21 sky130_fd_sc_hd__inv_1
X6_inv22 x6_n21 0 0 VPWR VPWR x6_n22 sky130_fd_sc_hd__inv_1
X6_inv23 x6_n22 0 0 VPWR VPWR x6_n23 sky130_fd_sc_hd__inv_1
X6_inv24 x6_n23 0 0 VPWR VPWR x6_n24 sky130_fd_sc_hd__inv_1
X6_inv25 x6_n24 0 0 VPWR VPWR x6_n25 sky130_fd_sc_hd__inv_1
X6_inv26 x6_n25 0 0 VPWR VPWR x6_n26 sky130_fd_sc_hd__inv_1
X6_inv27 x6_n26 0 0 VPWR VPWR x6_n27 sky130_fd_sc_hd__inv_1
X6_inv28 x6_n27 0 0 VPWR VPWR x6_n28 sky130_fd_sc_hd__inv_1
X6_inv29 x6_n28 0 0 VPWR VPWR x6_n29 sky130_fd_sc_hd__inv_1
X6_inv30 x6_n29 0 0 VPWR VPWR x6_n30 sky130_fd_sc_hd__inv_1
X6_buf x6_n15 0 0 VPWR VPWR x6_out sky130_fd_sc_hd__buf_1
C6_n0 x6_n0 0 4.707530e-16
C6_n1 x6_n1 0 4.604270e-16
C6_n2 x6_n2 0 4.824870e-16
C6_n3 x6_n3 0 2.925820e-16
C6_n4 x6_n4 0 7.623480e-16
C6_n5 x6_n5 0 5.421100e-16
C6_n6 x6_n6 0 3.238350e-16
C6_n7 x6_n7 0 9.395760e-16
C6_n8 x6_n8 0 1.349810e-16
C6_n9 x6_n9 0 1.098220e-16
C6_n10 x6_n10 0 3.925820e-16
C6_n11 x6_n11 0 3.547780e-16
C6_n12 x6_n12 0 8.126900e-16
C6_n13 x6_n13 0 3.154800e-16
C6_n14 x6_n14 0 6.017900e-16
C6_n15 x6_n15 0 1.317490e-15
C6_n16 x6_n16 0 8.674660e-16
C6_n17 x6_n17 0 3.268120e-16
C6_n18 x6_n18 0 3.079300e-16
C6_n19 x6_n19 0 3.626270e-16
C6_n20 x6_n20 0 3.079490e-16
C6_n21 x6_n21 0 6.005550e-16
C6_n22 x6_n22 0 2.927860e-16
C6_n23 x6_n23 0 4.302350e-16
C6_n24 x6_n24 0 2.906890e-16
C6_n25 x6_n25 0 3.516300e-16
C6_n26 x6_n26 0 3.649640e-16
C6_n27 x6_n27 0 5.129170e-16
C6_n28 x6_n28 0 1.628300e-16
C6_n29 x6_n29 0 2.373590e-16
C6_n30 x6_n30 0 6.248140e-16
C6_out x6_out 0 5.737230e-15
* --- RO 7 ---
X7_nand EN x7_n30 0 0 VPWR VPWR x7_n0 sky130_fd_sc_hd__nand2_1
X7_inv1 x7_n0 0 0 VPWR VPWR x7_n1 sky130_fd_sc_hd__inv_1
X7_inv2 x7_n1 0 0 VPWR VPWR x7_n2 sky130_fd_sc_hd__inv_1
X7_inv3 x7_n2 0 0 VPWR VPWR x7_n3 sky130_fd_sc_hd__inv_1
X7_inv4 x7_n3 0 0 VPWR VPWR x7_n4 sky130_fd_sc_hd__inv_1
X7_inv5 x7_n4 0 0 VPWR VPWR x7_n5 sky130_fd_sc_hd__inv_1
X7_inv6 x7_n5 0 0 VPWR VPWR x7_n6 sky130_fd_sc_hd__inv_1
X7_inv7 x7_n6 0 0 VPWR VPWR x7_n7 sky130_fd_sc_hd__inv_1
X7_inv8 x7_n7 0 0 VPWR VPWR x7_n8 sky130_fd_sc_hd__inv_1
X7_inv9 x7_n8 0 0 VPWR VPWR x7_n9 sky130_fd_sc_hd__inv_1
X7_inv10 x7_n9 0 0 VPWR VPWR x7_n10 sky130_fd_sc_hd__inv_1
X7_inv11 x7_n10 0 0 VPWR VPWR x7_n11 sky130_fd_sc_hd__inv_1
X7_inv12 x7_n11 0 0 VPWR VPWR x7_n12 sky130_fd_sc_hd__inv_1
X7_inv13 x7_n12 0 0 VPWR VPWR x7_n13 sky130_fd_sc_hd__inv_1
X7_inv14 x7_n13 0 0 VPWR VPWR x7_n14 sky130_fd_sc_hd__inv_1
X7_inv15 x7_n14 0 0 VPWR VPWR x7_n15 sky130_fd_sc_hd__inv_1
X7_inv16 x7_n15 0 0 VPWR VPWR x7_n16 sky130_fd_sc_hd__inv_1
X7_inv17 x7_n16 0 0 VPWR VPWR x7_n17 sky130_fd_sc_hd__inv_1
X7_inv18 x7_n17 0 0 VPWR VPWR x7_n18 sky130_fd_sc_hd__inv_1
X7_inv19 x7_n18 0 0 VPWR VPWR x7_n19 sky130_fd_sc_hd__inv_1
X7_inv20 x7_n19 0 0 VPWR VPWR x7_n20 sky130_fd_sc_hd__inv_1
X7_inv21 x7_n20 0 0 VPWR VPWR x7_n21 sky130_fd_sc_hd__inv_1
X7_inv22 x7_n21 0 0 VPWR VPWR x7_n22 sky130_fd_sc_hd__inv_1
X7_inv23 x7_n22 0 0 VPWR VPWR x7_n23 sky130_fd_sc_hd__inv_1
X7_inv24 x7_n23 0 0 VPWR VPWR x7_n24 sky130_fd_sc_hd__inv_1
X7_inv25 x7_n24 0 0 VPWR VPWR x7_n25 sky130_fd_sc_hd__inv_1
X7_inv26 x7_n25 0 0 VPWR VPWR x7_n26 sky130_fd_sc_hd__inv_1
X7_inv27 x7_n26 0 0 VPWR VPWR x7_n27 sky130_fd_sc_hd__inv_1
X7_inv28 x7_n27 0 0 VPWR VPWR x7_n28 sky130_fd_sc_hd__inv_1
X7_inv29 x7_n28 0 0 VPWR VPWR x7_n29 sky130_fd_sc_hd__inv_1
X7_inv30 x7_n29 0 0 VPWR VPWR x7_n30 sky130_fd_sc_hd__inv_1
X7_buf x7_n15 0 0 VPWR VPWR x7_out sky130_fd_sc_hd__buf_1
C7_n0 x7_n0 0 2.950550e-16
C7_n1 x7_n1 0 5.637060e-16
C7_n2 x7_n2 0 3.120520e-16
C7_n3 x7_n3 0 2.433310e-16
C7_n4 x7_n4 0 2.045530e-16
C7_n5 x7_n5 0 1.197900e-16
C7_n6 x7_n6 0 5.470910e-16
C7_n7 x7_n7 0 3.511420e-16
C7_n8 x7_n8 0 6.459410e-16
C7_n9 x7_n9 0 6.574450e-16
C7_n10 x7_n10 0 3.921620e-16
C7_n11 x7_n11 0 4.527410e-16
C7_n12 x7_n12 0 5.374450e-16
C7_n13 x7_n13 0 6.856000e-16
C7_n14 x7_n14 0 3.657060e-16
C7_n15 x7_n15 0 1.015440e-15
C7_n16 x7_n16 0 1.705300e-16
C7_n17 x7_n17 0 2.421590e-16
C7_n18 x7_n18 0 1.564940e-16
C7_n19 x7_n19 0 1.564940e-16
C7_n20 x7_n20 0 1.628300e-16
C7_n21 x7_n21 0 5.517980e-16
C7_n22 x7_n22 0 1.067930e-16
C7_n23 x7_n23 0 1.067930e-16
C7_n24 x7_n24 0 4.634280e-16
C7_n25 x7_n25 0 7.268060e-16
C7_n26 x7_n26 0 3.411640e-16
C7_n27 x7_n27 0 3.624810e-16
C7_n28 x7_n28 0 3.423670e-16
C7_n29 x7_n29 0 5.246380e-16
C7_n30 x7_n30 0 5.607960e-16
C7_out x7_out 0 4.904490e-15
* --- RO 8 ---
X8_nand EN x8_n30 0 0 VPWR VPWR x8_n0 sky130_fd_sc_hd__nand2_1
X8_inv1 x8_n0 0 0 VPWR VPWR x8_n1 sky130_fd_sc_hd__inv_1
X8_inv2 x8_n1 0 0 VPWR VPWR x8_n2 sky130_fd_sc_hd__inv_1
X8_inv3 x8_n2 0 0 VPWR VPWR x8_n3 sky130_fd_sc_hd__inv_1
X8_inv4 x8_n3 0 0 VPWR VPWR x8_n4 sky130_fd_sc_hd__inv_1
X8_inv5 x8_n4 0 0 VPWR VPWR x8_n5 sky130_fd_sc_hd__inv_1
X8_inv6 x8_n5 0 0 VPWR VPWR x8_n6 sky130_fd_sc_hd__inv_1
X8_inv7 x8_n6 0 0 VPWR VPWR x8_n7 sky130_fd_sc_hd__inv_1
X8_inv8 x8_n7 0 0 VPWR VPWR x8_n8 sky130_fd_sc_hd__inv_1
X8_inv9 x8_n8 0 0 VPWR VPWR x8_n9 sky130_fd_sc_hd__inv_1
X8_inv10 x8_n9 0 0 VPWR VPWR x8_n10 sky130_fd_sc_hd__inv_1
X8_inv11 x8_n10 0 0 VPWR VPWR x8_n11 sky130_fd_sc_hd__inv_1
X8_inv12 x8_n11 0 0 VPWR VPWR x8_n12 sky130_fd_sc_hd__inv_1
X8_inv13 x8_n12 0 0 VPWR VPWR x8_n13 sky130_fd_sc_hd__inv_1
X8_inv14 x8_n13 0 0 VPWR VPWR x8_n14 sky130_fd_sc_hd__inv_1
X8_inv15 x8_n14 0 0 VPWR VPWR x8_n15 sky130_fd_sc_hd__inv_1
X8_inv16 x8_n15 0 0 VPWR VPWR x8_n16 sky130_fd_sc_hd__inv_1
X8_inv17 x8_n16 0 0 VPWR VPWR x8_n17 sky130_fd_sc_hd__inv_1
X8_inv18 x8_n17 0 0 VPWR VPWR x8_n18 sky130_fd_sc_hd__inv_1
X8_inv19 x8_n18 0 0 VPWR VPWR x8_n19 sky130_fd_sc_hd__inv_1
X8_inv20 x8_n19 0 0 VPWR VPWR x8_n20 sky130_fd_sc_hd__inv_1
X8_inv21 x8_n20 0 0 VPWR VPWR x8_n21 sky130_fd_sc_hd__inv_1
X8_inv22 x8_n21 0 0 VPWR VPWR x8_n22 sky130_fd_sc_hd__inv_1
X8_inv23 x8_n22 0 0 VPWR VPWR x8_n23 sky130_fd_sc_hd__inv_1
X8_inv24 x8_n23 0 0 VPWR VPWR x8_n24 sky130_fd_sc_hd__inv_1
X8_inv25 x8_n24 0 0 VPWR VPWR x8_n25 sky130_fd_sc_hd__inv_1
X8_inv26 x8_n25 0 0 VPWR VPWR x8_n26 sky130_fd_sc_hd__inv_1
X8_inv27 x8_n26 0 0 VPWR VPWR x8_n27 sky130_fd_sc_hd__inv_1
X8_inv28 x8_n27 0 0 VPWR VPWR x8_n28 sky130_fd_sc_hd__inv_1
X8_inv29 x8_n28 0 0 VPWR VPWR x8_n29 sky130_fd_sc_hd__inv_1
X8_inv30 x8_n29 0 0 VPWR VPWR x8_n30 sky130_fd_sc_hd__inv_1
X8_buf x8_n15 0 0 VPWR VPWR x8_out sky130_fd_sc_hd__buf_1
C8_n0 x8_n0 0 5.351160e-16
C8_n1 x8_n1 0 4.736980e-16
C8_n2 x8_n2 0 6.105730e-16
C8_n3 x8_n3 0 7.535870e-16
C8_n4 x8_n4 0 1.080010e-15
C8_n5 x8_n5 0 4.347030e-16
C8_n6 x8_n6 0 7.613050e-16
C8_n7 x8_n7 0 6.433050e-16
C8_n8 x8_n8 0 5.525860e-16
C8_n9 x8_n9 0 6.092980e-16
C8_n10 x8_n10 0 2.852130e-16
C8_n11 x8_n11 0 3.894660e-16
C8_n12 x8_n12 0 8.530340e-16
C8_n13 x8_n13 0 4.345670e-16
C8_n14 x8_n14 0 6.285860e-16
C8_n15 x8_n15 0 1.224600e-15
C8_n16 x8_n16 0 1.747980e-16
C8_n17 x8_n17 0 1.769660e-16
C8_n18 x8_n18 0 6.169590e-16
C8_n19 x8_n19 0 8.311410e-16
C8_n20 x8_n20 0 2.548050e-16
C8_n21 x8_n21 0 2.548050e-16
C8_n22 x8_n22 0 1.747980e-16
C8_n23 x8_n23 0 4.420660e-16
C8_n24 x8_n24 0 1.628300e-16
C8_n25 x8_n25 0 8.223180e-16
C8_n26 x8_n26 0 4.375350e-16
C8_n27 x8_n27 0 7.337050e-16
C8_n28 x8_n28 0 1.720590e-16
C8_n29 x8_n29 0 3.518390e-16
C8_n30 x8_n30 0 3.677370e-16
C8_out x8_out 0 6.143960e-15
* --- RO 9 ---
X9_nand EN x9_n30 0 0 VPWR VPWR x9_n0 sky130_fd_sc_hd__nand2_1
X9_inv1 x9_n0 0 0 VPWR VPWR x9_n1 sky130_fd_sc_hd__inv_1
X9_inv2 x9_n1 0 0 VPWR VPWR x9_n2 sky130_fd_sc_hd__inv_1
X9_inv3 x9_n2 0 0 VPWR VPWR x9_n3 sky130_fd_sc_hd__inv_1
X9_inv4 x9_n3 0 0 VPWR VPWR x9_n4 sky130_fd_sc_hd__inv_1
X9_inv5 x9_n4 0 0 VPWR VPWR x9_n5 sky130_fd_sc_hd__inv_1
X9_inv6 x9_n5 0 0 VPWR VPWR x9_n6 sky130_fd_sc_hd__inv_1
X9_inv7 x9_n6 0 0 VPWR VPWR x9_n7 sky130_fd_sc_hd__inv_1
X9_inv8 x9_n7 0 0 VPWR VPWR x9_n8 sky130_fd_sc_hd__inv_1
X9_inv9 x9_n8 0 0 VPWR VPWR x9_n9 sky130_fd_sc_hd__inv_1
X9_inv10 x9_n9 0 0 VPWR VPWR x9_n10 sky130_fd_sc_hd__inv_1
X9_inv11 x9_n10 0 0 VPWR VPWR x9_n11 sky130_fd_sc_hd__inv_1
X9_inv12 x9_n11 0 0 VPWR VPWR x9_n12 sky130_fd_sc_hd__inv_1
X9_inv13 x9_n12 0 0 VPWR VPWR x9_n13 sky130_fd_sc_hd__inv_1
X9_inv14 x9_n13 0 0 VPWR VPWR x9_n14 sky130_fd_sc_hd__inv_1
X9_inv15 x9_n14 0 0 VPWR VPWR x9_n15 sky130_fd_sc_hd__inv_1
X9_inv16 x9_n15 0 0 VPWR VPWR x9_n16 sky130_fd_sc_hd__inv_1
X9_inv17 x9_n16 0 0 VPWR VPWR x9_n17 sky130_fd_sc_hd__inv_1
X9_inv18 x9_n17 0 0 VPWR VPWR x9_n18 sky130_fd_sc_hd__inv_1
X9_inv19 x9_n18 0 0 VPWR VPWR x9_n19 sky130_fd_sc_hd__inv_1
X9_inv20 x9_n19 0 0 VPWR VPWR x9_n20 sky130_fd_sc_hd__inv_1
X9_inv21 x9_n20 0 0 VPWR VPWR x9_n21 sky130_fd_sc_hd__inv_1
X9_inv22 x9_n21 0 0 VPWR VPWR x9_n22 sky130_fd_sc_hd__inv_1
X9_inv23 x9_n22 0 0 VPWR VPWR x9_n23 sky130_fd_sc_hd__inv_1
X9_inv24 x9_n23 0 0 VPWR VPWR x9_n24 sky130_fd_sc_hd__inv_1
X9_inv25 x9_n24 0 0 VPWR VPWR x9_n25 sky130_fd_sc_hd__inv_1
X9_inv26 x9_n25 0 0 VPWR VPWR x9_n26 sky130_fd_sc_hd__inv_1
X9_inv27 x9_n26 0 0 VPWR VPWR x9_n27 sky130_fd_sc_hd__inv_1
X9_inv28 x9_n27 0 0 VPWR VPWR x9_n28 sky130_fd_sc_hd__inv_1
X9_inv29 x9_n28 0 0 VPWR VPWR x9_n29 sky130_fd_sc_hd__inv_1
X9_inv30 x9_n29 0 0 VPWR VPWR x9_n30 sky130_fd_sc_hd__inv_1
X9_buf x9_n15 0 0 VPWR VPWR x9_out sky130_fd_sc_hd__buf_1
C9_n0 x9_n0 0 6.444470e-16
C9_n1 x9_n1 0 4.799280e-16
C9_n2 x9_n2 0 4.110750e-16
C9_n3 x9_n3 0 1.677060e-16
C9_n4 x9_n4 0 5.077790e-16
C9_n5 x9_n5 0 1.628300e-16
C9_n6 x9_n6 0 6.030010e-16
C9_n7 x9_n7 0 7.261390e-16
C9_n8 x9_n8 0 3.449210e-16
C9_n9 x9_n9 0 4.092060e-16
C9_n10 x9_n10 0 7.513920e-16
C9_n11 x9_n11 0 4.805010e-16
C9_n12 x9_n12 0 1.628300e-16
C9_n13 x9_n13 0 1.015430e-15
C9_n14 x9_n14 0 2.381190e-16
C9_n15 x9_n15 0 1.269170e-15
C9_n16 x9_n16 0 4.716850e-16
C9_n17 x9_n17 0 5.292450e-16
C9_n18 x9_n18 0 1.556730e-16
C9_n19 x9_n19 0 1.067930e-16
C9_n20 x9_n20 0 3.649530e-16
C9_n21 x9_n21 0 1.978710e-16
C9_n22 x9_n22 0 3.682800e-16
C9_n23 x9_n23 0 3.998570e-16
C9_n24 x9_n24 0 6.531330e-16
C9_n25 x9_n25 0 6.942510e-16
C9_n26 x9_n26 0 3.588710e-16
C9_n27 x9_n27 0 3.483740e-16
C9_n28 x9_n28 0 4.113840e-16
C9_n29 x9_n29 0 4.255320e-16
C9_n30 x9_n30 0 1.120720e-15
C9_out x9_out 0 4.940520e-15
* --- RO 10 ---
X10_nand EN x10_n30 0 0 VPWR VPWR x10_n0 sky130_fd_sc_hd__nand2_1
X10_inv1 x10_n0 0 0 VPWR VPWR x10_n1 sky130_fd_sc_hd__inv_1
X10_inv2 x10_n1 0 0 VPWR VPWR x10_n2 sky130_fd_sc_hd__inv_1
X10_inv3 x10_n2 0 0 VPWR VPWR x10_n3 sky130_fd_sc_hd__inv_1
X10_inv4 x10_n3 0 0 VPWR VPWR x10_n4 sky130_fd_sc_hd__inv_1
X10_inv5 x10_n4 0 0 VPWR VPWR x10_n5 sky130_fd_sc_hd__inv_1
X10_inv6 x10_n5 0 0 VPWR VPWR x10_n6 sky130_fd_sc_hd__inv_1
X10_inv7 x10_n6 0 0 VPWR VPWR x10_n7 sky130_fd_sc_hd__inv_1
X10_inv8 x10_n7 0 0 VPWR VPWR x10_n8 sky130_fd_sc_hd__inv_1
X10_inv9 x10_n8 0 0 VPWR VPWR x10_n9 sky130_fd_sc_hd__inv_1
X10_inv10 x10_n9 0 0 VPWR VPWR x10_n10 sky130_fd_sc_hd__inv_1
X10_inv11 x10_n10 0 0 VPWR VPWR x10_n11 sky130_fd_sc_hd__inv_1
X10_inv12 x10_n11 0 0 VPWR VPWR x10_n12 sky130_fd_sc_hd__inv_1
X10_inv13 x10_n12 0 0 VPWR VPWR x10_n13 sky130_fd_sc_hd__inv_1
X10_inv14 x10_n13 0 0 VPWR VPWR x10_n14 sky130_fd_sc_hd__inv_1
X10_inv15 x10_n14 0 0 VPWR VPWR x10_n15 sky130_fd_sc_hd__inv_1
X10_inv16 x10_n15 0 0 VPWR VPWR x10_n16 sky130_fd_sc_hd__inv_1
X10_inv17 x10_n16 0 0 VPWR VPWR x10_n17 sky130_fd_sc_hd__inv_1
X10_inv18 x10_n17 0 0 VPWR VPWR x10_n18 sky130_fd_sc_hd__inv_1
X10_inv19 x10_n18 0 0 VPWR VPWR x10_n19 sky130_fd_sc_hd__inv_1
X10_inv20 x10_n19 0 0 VPWR VPWR x10_n20 sky130_fd_sc_hd__inv_1
X10_inv21 x10_n20 0 0 VPWR VPWR x10_n21 sky130_fd_sc_hd__inv_1
X10_inv22 x10_n21 0 0 VPWR VPWR x10_n22 sky130_fd_sc_hd__inv_1
X10_inv23 x10_n22 0 0 VPWR VPWR x10_n23 sky130_fd_sc_hd__inv_1
X10_inv24 x10_n23 0 0 VPWR VPWR x10_n24 sky130_fd_sc_hd__inv_1
X10_inv25 x10_n24 0 0 VPWR VPWR x10_n25 sky130_fd_sc_hd__inv_1
X10_inv26 x10_n25 0 0 VPWR VPWR x10_n26 sky130_fd_sc_hd__inv_1
X10_inv27 x10_n26 0 0 VPWR VPWR x10_n27 sky130_fd_sc_hd__inv_1
X10_inv28 x10_n27 0 0 VPWR VPWR x10_n28 sky130_fd_sc_hd__inv_1
X10_inv29 x10_n28 0 0 VPWR VPWR x10_n29 sky130_fd_sc_hd__inv_1
X10_inv30 x10_n29 0 0 VPWR VPWR x10_n30 sky130_fd_sc_hd__inv_1
X10_buf x10_n15 0 0 VPWR VPWR x10_out sky130_fd_sc_hd__buf_1
C10_n0 x10_n0 0 2.667910e-16
C10_n1 x10_n1 0 4.481230e-16
C10_n2 x10_n2 0 1.628300e-16
C10_n3 x10_n3 0 6.926210e-16
C10_n4 x10_n4 0 1.656970e-16
C10_n5 x10_n5 0 3.624350e-16
C10_n6 x10_n6 0 3.195760e-16
C10_n7 x10_n7 0 3.251590e-16
C10_n8 x10_n8 0 2.865270e-16
C10_n9 x10_n9 0 7.601090e-16
C10_n10 x10_n10 0 3.924790e-16
C10_n11 x10_n11 0 5.619900e-16
C10_n12 x10_n12 0 6.226810e-16
C10_n13 x10_n13 0 1.135650e-16
C10_n14 x10_n14 0 1.135580e-16
C10_n15 x10_n15 0 9.101370e-16
C10_n16 x10_n16 0 5.487890e-16
C10_n17 x10_n17 0 5.584240e-16
C10_n18 x10_n18 0 5.920440e-16
C10_n19 x10_n19 0 1.236550e-16
C10_n20 x10_n20 0 1.297670e-16
C10_n21 x10_n21 0 8.009460e-16
C10_n22 x10_n22 0 6.476390e-16
C10_n23 x10_n23 0 6.739630e-16
C10_n24 x10_n24 0 1.872780e-16
C10_n25 x10_n25 0 6.773070e-16
C10_n26 x10_n26 0 1.777440e-16
C10_n27 x10_n27 0 8.813940e-16
C10_n28 x10_n28 0 4.490890e-16
C10_n29 x10_n29 0 4.773620e-16
C10_n30 x10_n30 0 7.942340e-16
C10_out x10_out 0 5.474180e-15
* --- RO 11 ---
X11_nand EN x11_n30 0 0 VPWR VPWR x11_n0 sky130_fd_sc_hd__nand2_1
X11_inv1 x11_n0 0 0 VPWR VPWR x11_n1 sky130_fd_sc_hd__inv_1
X11_inv2 x11_n1 0 0 VPWR VPWR x11_n2 sky130_fd_sc_hd__inv_1
X11_inv3 x11_n2 0 0 VPWR VPWR x11_n3 sky130_fd_sc_hd__inv_1
X11_inv4 x11_n3 0 0 VPWR VPWR x11_n4 sky130_fd_sc_hd__inv_1
X11_inv5 x11_n4 0 0 VPWR VPWR x11_n5 sky130_fd_sc_hd__inv_1
X11_inv6 x11_n5 0 0 VPWR VPWR x11_n6 sky130_fd_sc_hd__inv_1
X11_inv7 x11_n6 0 0 VPWR VPWR x11_n7 sky130_fd_sc_hd__inv_1
X11_inv8 x11_n7 0 0 VPWR VPWR x11_n8 sky130_fd_sc_hd__inv_1
X11_inv9 x11_n8 0 0 VPWR VPWR x11_n9 sky130_fd_sc_hd__inv_1
X11_inv10 x11_n9 0 0 VPWR VPWR x11_n10 sky130_fd_sc_hd__inv_1
X11_inv11 x11_n10 0 0 VPWR VPWR x11_n11 sky130_fd_sc_hd__inv_1
X11_inv12 x11_n11 0 0 VPWR VPWR x11_n12 sky130_fd_sc_hd__inv_1
X11_inv13 x11_n12 0 0 VPWR VPWR x11_n13 sky130_fd_sc_hd__inv_1
X11_inv14 x11_n13 0 0 VPWR VPWR x11_n14 sky130_fd_sc_hd__inv_1
X11_inv15 x11_n14 0 0 VPWR VPWR x11_n15 sky130_fd_sc_hd__inv_1
X11_inv16 x11_n15 0 0 VPWR VPWR x11_n16 sky130_fd_sc_hd__inv_1
X11_inv17 x11_n16 0 0 VPWR VPWR x11_n17 sky130_fd_sc_hd__inv_1
X11_inv18 x11_n17 0 0 VPWR VPWR x11_n18 sky130_fd_sc_hd__inv_1
X11_inv19 x11_n18 0 0 VPWR VPWR x11_n19 sky130_fd_sc_hd__inv_1
X11_inv20 x11_n19 0 0 VPWR VPWR x11_n20 sky130_fd_sc_hd__inv_1
X11_inv21 x11_n20 0 0 VPWR VPWR x11_n21 sky130_fd_sc_hd__inv_1
X11_inv22 x11_n21 0 0 VPWR VPWR x11_n22 sky130_fd_sc_hd__inv_1
X11_inv23 x11_n22 0 0 VPWR VPWR x11_n23 sky130_fd_sc_hd__inv_1
X11_inv24 x11_n23 0 0 VPWR VPWR x11_n24 sky130_fd_sc_hd__inv_1
X11_inv25 x11_n24 0 0 VPWR VPWR x11_n25 sky130_fd_sc_hd__inv_1
X11_inv26 x11_n25 0 0 VPWR VPWR x11_n26 sky130_fd_sc_hd__inv_1
X11_inv27 x11_n26 0 0 VPWR VPWR x11_n27 sky130_fd_sc_hd__inv_1
X11_inv28 x11_n27 0 0 VPWR VPWR x11_n28 sky130_fd_sc_hd__inv_1
X11_inv29 x11_n28 0 0 VPWR VPWR x11_n29 sky130_fd_sc_hd__inv_1
X11_inv30 x11_n29 0 0 VPWR VPWR x11_n30 sky130_fd_sc_hd__inv_1
X11_buf x11_n15 0 0 VPWR VPWR x11_out sky130_fd_sc_hd__buf_1
C11_n0 x11_n0 0 2.358630e-16
C11_n1 x11_n1 0 9.988410e-16
C11_n2 x11_n2 0 1.233470e-16
C11_n3 x11_n3 0 5.855540e-16
C11_n4 x11_n4 0 5.542620e-16
C11_n5 x11_n5 0 6.941040e-16
C11_n6 x11_n6 0 1.285880e-16
C11_n7 x11_n7 0 2.321480e-16
C11_n8 x11_n8 0 1.285880e-16
C11_n9 x11_n9 0 1.131280e-16
C11_n10 x11_n10 0 4.158860e-16
C11_n11 x11_n11 0 2.126860e-16
C11_n12 x11_n12 0 1.070650e-16
C11_n13 x11_n13 0 1.070650e-16
C11_n14 x11_n14 0 1.087680e-16
C11_n15 x11_n15 0 5.734380e-16
C11_n16 x11_n16 0 3.055280e-16
C11_n17 x11_n17 0 3.114800e-16
C11_n18 x11_n18 0 3.502380e-16
C11_n19 x11_n19 0 2.525270e-16
C11_n20 x11_n20 0 1.798000e-16
C11_n21 x11_n21 0 8.989300e-16
C11_n22 x11_n22 0 8.240310e-16
C11_n23 x11_n23 0 4.588300e-16
C11_n24 x11_n24 0 3.493430e-16
C11_n25 x11_n25 0 4.395830e-16
C11_n26 x11_n26 0 5.109480e-16
C11_n27 x11_n27 0 2.862570e-16
C11_n28 x11_n28 0 4.084270e-16
C11_n29 x11_n29 0 1.042390e-15
C11_n30 x11_n30 0 4.187730e-16
C11_out x11_out 0 6.385900e-15
* --- RO 12 ---
X12_nand EN x12_n30 0 0 VPWR VPWR x12_n0 sky130_fd_sc_hd__nand2_1
X12_inv1 x12_n0 0 0 VPWR VPWR x12_n1 sky130_fd_sc_hd__inv_1
X12_inv2 x12_n1 0 0 VPWR VPWR x12_n2 sky130_fd_sc_hd__inv_1
X12_inv3 x12_n2 0 0 VPWR VPWR x12_n3 sky130_fd_sc_hd__inv_1
X12_inv4 x12_n3 0 0 VPWR VPWR x12_n4 sky130_fd_sc_hd__inv_1
X12_inv5 x12_n4 0 0 VPWR VPWR x12_n5 sky130_fd_sc_hd__inv_1
X12_inv6 x12_n5 0 0 VPWR VPWR x12_n6 sky130_fd_sc_hd__inv_1
X12_inv7 x12_n6 0 0 VPWR VPWR x12_n7 sky130_fd_sc_hd__inv_1
X12_inv8 x12_n7 0 0 VPWR VPWR x12_n8 sky130_fd_sc_hd__inv_1
X12_inv9 x12_n8 0 0 VPWR VPWR x12_n9 sky130_fd_sc_hd__inv_1
X12_inv10 x12_n9 0 0 VPWR VPWR x12_n10 sky130_fd_sc_hd__inv_1
X12_inv11 x12_n10 0 0 VPWR VPWR x12_n11 sky130_fd_sc_hd__inv_1
X12_inv12 x12_n11 0 0 VPWR VPWR x12_n12 sky130_fd_sc_hd__inv_1
X12_inv13 x12_n12 0 0 VPWR VPWR x12_n13 sky130_fd_sc_hd__inv_1
X12_inv14 x12_n13 0 0 VPWR VPWR x12_n14 sky130_fd_sc_hd__inv_1
X12_inv15 x12_n14 0 0 VPWR VPWR x12_n15 sky130_fd_sc_hd__inv_1
X12_inv16 x12_n15 0 0 VPWR VPWR x12_n16 sky130_fd_sc_hd__inv_1
X12_inv17 x12_n16 0 0 VPWR VPWR x12_n17 sky130_fd_sc_hd__inv_1
X12_inv18 x12_n17 0 0 VPWR VPWR x12_n18 sky130_fd_sc_hd__inv_1
X12_inv19 x12_n18 0 0 VPWR VPWR x12_n19 sky130_fd_sc_hd__inv_1
X12_inv20 x12_n19 0 0 VPWR VPWR x12_n20 sky130_fd_sc_hd__inv_1
X12_inv21 x12_n20 0 0 VPWR VPWR x12_n21 sky130_fd_sc_hd__inv_1
X12_inv22 x12_n21 0 0 VPWR VPWR x12_n22 sky130_fd_sc_hd__inv_1
X12_inv23 x12_n22 0 0 VPWR VPWR x12_n23 sky130_fd_sc_hd__inv_1
X12_inv24 x12_n23 0 0 VPWR VPWR x12_n24 sky130_fd_sc_hd__inv_1
X12_inv25 x12_n24 0 0 VPWR VPWR x12_n25 sky130_fd_sc_hd__inv_1
X12_inv26 x12_n25 0 0 VPWR VPWR x12_n26 sky130_fd_sc_hd__inv_1
X12_inv27 x12_n26 0 0 VPWR VPWR x12_n27 sky130_fd_sc_hd__inv_1
X12_inv28 x12_n27 0 0 VPWR VPWR x12_n28 sky130_fd_sc_hd__inv_1
X12_inv29 x12_n28 0 0 VPWR VPWR x12_n29 sky130_fd_sc_hd__inv_1
X12_inv30 x12_n29 0 0 VPWR VPWR x12_n30 sky130_fd_sc_hd__inv_1
X12_buf x12_n15 0 0 VPWR VPWR x12_out sky130_fd_sc_hd__buf_1
C12_n0 x12_n0 0 3.597570e-16
C12_n1 x12_n1 0 2.018600e-16
C12_n2 x12_n2 0 1.998010e-16
C12_n3 x12_n3 0 4.578750e-16
C12_n4 x12_n4 0 6.363770e-16
C12_n5 x12_n5 0 2.373590e-16
C12_n6 x12_n6 0 3.967490e-16
C12_n7 x12_n7 0 1.634230e-16
C12_n8 x12_n8 0 8.610880e-16
C12_n9 x12_n9 0 8.510780e-16
C12_n10 x12_n10 0 4.521450e-16
C12_n11 x12_n11 0 1.380790e-15
C12_n12 x12_n12 0 4.955020e-16
C12_n13 x12_n13 0 1.122770e-15
C12_n14 x12_n14 0 9.658980e-16
C12_n15 x12_n15 0 8.299740e-16
C12_n16 x12_n16 0 5.151320e-16
C12_n17 x12_n17 0 3.857600e-16
C12_n18 x12_n18 0 3.282820e-16
C12_n19 x12_n19 0 2.442990e-16
C12_n20 x12_n20 0 2.281230e-16
C12_n21 x12_n21 0 4.337440e-16
C12_n22 x12_n22 0 1.633320e-16
C12_n23 x12_n23 0 5.835700e-16
C12_n24 x12_n24 0 5.570710e-16
C12_n25 x12_n25 0 4.146350e-16
C12_n26 x12_n26 0 3.348880e-16
C12_n27 x12_n27 0 3.448760e-16
C12_n28 x12_n28 0 6.162140e-16
C12_n29 x12_n29 0 4.652610e-16
C12_n30 x12_n30 0 1.258740e-15
C12_out x12_out 0 6.959290e-15
* --- RO 13 ---
X13_nand EN x13_n30 0 0 VPWR VPWR x13_n0 sky130_fd_sc_hd__nand2_1
X13_inv1 x13_n0 0 0 VPWR VPWR x13_n1 sky130_fd_sc_hd__inv_1
X13_inv2 x13_n1 0 0 VPWR VPWR x13_n2 sky130_fd_sc_hd__inv_1
X13_inv3 x13_n2 0 0 VPWR VPWR x13_n3 sky130_fd_sc_hd__inv_1
X13_inv4 x13_n3 0 0 VPWR VPWR x13_n4 sky130_fd_sc_hd__inv_1
X13_inv5 x13_n4 0 0 VPWR VPWR x13_n5 sky130_fd_sc_hd__inv_1
X13_inv6 x13_n5 0 0 VPWR VPWR x13_n6 sky130_fd_sc_hd__inv_1
X13_inv7 x13_n6 0 0 VPWR VPWR x13_n7 sky130_fd_sc_hd__inv_1
X13_inv8 x13_n7 0 0 VPWR VPWR x13_n8 sky130_fd_sc_hd__inv_1
X13_inv9 x13_n8 0 0 VPWR VPWR x13_n9 sky130_fd_sc_hd__inv_1
X13_inv10 x13_n9 0 0 VPWR VPWR x13_n10 sky130_fd_sc_hd__inv_1
X13_inv11 x13_n10 0 0 VPWR VPWR x13_n11 sky130_fd_sc_hd__inv_1
X13_inv12 x13_n11 0 0 VPWR VPWR x13_n12 sky130_fd_sc_hd__inv_1
X13_inv13 x13_n12 0 0 VPWR VPWR x13_n13 sky130_fd_sc_hd__inv_1
X13_inv14 x13_n13 0 0 VPWR VPWR x13_n14 sky130_fd_sc_hd__inv_1
X13_inv15 x13_n14 0 0 VPWR VPWR x13_n15 sky130_fd_sc_hd__inv_1
X13_inv16 x13_n15 0 0 VPWR VPWR x13_n16 sky130_fd_sc_hd__inv_1
X13_inv17 x13_n16 0 0 VPWR VPWR x13_n17 sky130_fd_sc_hd__inv_1
X13_inv18 x13_n17 0 0 VPWR VPWR x13_n18 sky130_fd_sc_hd__inv_1
X13_inv19 x13_n18 0 0 VPWR VPWR x13_n19 sky130_fd_sc_hd__inv_1
X13_inv20 x13_n19 0 0 VPWR VPWR x13_n20 sky130_fd_sc_hd__inv_1
X13_inv21 x13_n20 0 0 VPWR VPWR x13_n21 sky130_fd_sc_hd__inv_1
X13_inv22 x13_n21 0 0 VPWR VPWR x13_n22 sky130_fd_sc_hd__inv_1
X13_inv23 x13_n22 0 0 VPWR VPWR x13_n23 sky130_fd_sc_hd__inv_1
X13_inv24 x13_n23 0 0 VPWR VPWR x13_n24 sky130_fd_sc_hd__inv_1
X13_inv25 x13_n24 0 0 VPWR VPWR x13_n25 sky130_fd_sc_hd__inv_1
X13_inv26 x13_n25 0 0 VPWR VPWR x13_n26 sky130_fd_sc_hd__inv_1
X13_inv27 x13_n26 0 0 VPWR VPWR x13_n27 sky130_fd_sc_hd__inv_1
X13_inv28 x13_n27 0 0 VPWR VPWR x13_n28 sky130_fd_sc_hd__inv_1
X13_inv29 x13_n28 0 0 VPWR VPWR x13_n29 sky130_fd_sc_hd__inv_1
X13_inv30 x13_n29 0 0 VPWR VPWR x13_n30 sky130_fd_sc_hd__inv_1
X13_buf x13_n15 0 0 VPWR VPWR x13_out sky130_fd_sc_hd__buf_1
C13_n0 x13_n0 0 2.161830e-16
C13_n1 x13_n1 0 5.441570e-16
C13_n2 x13_n2 0 2.825330e-16
C13_n3 x13_n3 0 3.504180e-16
C13_n4 x13_n4 0 2.944140e-16
C13_n5 x13_n5 0 3.408880e-16
C13_n6 x13_n6 0 5.746430e-16
C13_n7 x13_n7 0 3.032680e-16
C13_n8 x13_n8 0 4.565420e-16
C13_n9 x13_n9 0 3.084090e-16
C13_n10 x13_n10 0 8.187620e-16
C13_n11 x13_n11 0 2.216490e-16
C13_n12 x13_n12 0 2.724770e-16
C13_n13 x13_n13 0 4.022500e-16
C13_n14 x13_n14 0 1.239240e-16
C13_n15 x13_n15 0 6.497290e-16
C13_n16 x13_n16 0 5.687420e-16
C13_n17 x13_n17 0 1.401830e-16
C13_n18 x13_n18 0 4.273980e-16
C13_n19 x13_n19 0 5.232330e-16
C13_n20 x13_n20 0 1.762210e-16
C13_n21 x13_n21 0 8.585260e-16
C13_n22 x13_n22 0 5.851080e-16
C13_n23 x13_n23 0 3.655850e-16
C13_n24 x13_n24 0 4.301570e-16
C13_n25 x13_n25 0 2.976320e-16
C13_n26 x13_n26 0 4.584690e-16
C13_n27 x13_n27 0 5.392220e-16
C13_n28 x13_n28 0 3.368280e-16
C13_n29 x13_n29 0 3.950150e-16
C13_n30 x13_n30 0 6.345920e-16
C13_out x13_out 0 5.075800e-15
* --- RO 14 ---
X14_nand EN x14_n30 0 0 VPWR VPWR x14_n0 sky130_fd_sc_hd__nand2_1
X14_inv1 x14_n0 0 0 VPWR VPWR x14_n1 sky130_fd_sc_hd__inv_1
X14_inv2 x14_n1 0 0 VPWR VPWR x14_n2 sky130_fd_sc_hd__inv_1
X14_inv3 x14_n2 0 0 VPWR VPWR x14_n3 sky130_fd_sc_hd__inv_1
X14_inv4 x14_n3 0 0 VPWR VPWR x14_n4 sky130_fd_sc_hd__inv_1
X14_inv5 x14_n4 0 0 VPWR VPWR x14_n5 sky130_fd_sc_hd__inv_1
X14_inv6 x14_n5 0 0 VPWR VPWR x14_n6 sky130_fd_sc_hd__inv_1
X14_inv7 x14_n6 0 0 VPWR VPWR x14_n7 sky130_fd_sc_hd__inv_1
X14_inv8 x14_n7 0 0 VPWR VPWR x14_n8 sky130_fd_sc_hd__inv_1
X14_inv9 x14_n8 0 0 VPWR VPWR x14_n9 sky130_fd_sc_hd__inv_1
X14_inv10 x14_n9 0 0 VPWR VPWR x14_n10 sky130_fd_sc_hd__inv_1
X14_inv11 x14_n10 0 0 VPWR VPWR x14_n11 sky130_fd_sc_hd__inv_1
X14_inv12 x14_n11 0 0 VPWR VPWR x14_n12 sky130_fd_sc_hd__inv_1
X14_inv13 x14_n12 0 0 VPWR VPWR x14_n13 sky130_fd_sc_hd__inv_1
X14_inv14 x14_n13 0 0 VPWR VPWR x14_n14 sky130_fd_sc_hd__inv_1
X14_inv15 x14_n14 0 0 VPWR VPWR x14_n15 sky130_fd_sc_hd__inv_1
X14_inv16 x14_n15 0 0 VPWR VPWR x14_n16 sky130_fd_sc_hd__inv_1
X14_inv17 x14_n16 0 0 VPWR VPWR x14_n17 sky130_fd_sc_hd__inv_1
X14_inv18 x14_n17 0 0 VPWR VPWR x14_n18 sky130_fd_sc_hd__inv_1
X14_inv19 x14_n18 0 0 VPWR VPWR x14_n19 sky130_fd_sc_hd__inv_1
X14_inv20 x14_n19 0 0 VPWR VPWR x14_n20 sky130_fd_sc_hd__inv_1
X14_inv21 x14_n20 0 0 VPWR VPWR x14_n21 sky130_fd_sc_hd__inv_1
X14_inv22 x14_n21 0 0 VPWR VPWR x14_n22 sky130_fd_sc_hd__inv_1
X14_inv23 x14_n22 0 0 VPWR VPWR x14_n23 sky130_fd_sc_hd__inv_1
X14_inv24 x14_n23 0 0 VPWR VPWR x14_n24 sky130_fd_sc_hd__inv_1
X14_inv25 x14_n24 0 0 VPWR VPWR x14_n25 sky130_fd_sc_hd__inv_1
X14_inv26 x14_n25 0 0 VPWR VPWR x14_n26 sky130_fd_sc_hd__inv_1
X14_inv27 x14_n26 0 0 VPWR VPWR x14_n27 sky130_fd_sc_hd__inv_1
X14_inv28 x14_n27 0 0 VPWR VPWR x14_n28 sky130_fd_sc_hd__inv_1
X14_inv29 x14_n28 0 0 VPWR VPWR x14_n29 sky130_fd_sc_hd__inv_1
X14_inv30 x14_n29 0 0 VPWR VPWR x14_n30 sky130_fd_sc_hd__inv_1
X14_buf x14_n15 0 0 VPWR VPWR x14_out sky130_fd_sc_hd__buf_1
C14_n0 x14_n0 0 6.060450e-16
C14_n1 x14_n1 0 1.632520e-16
C14_n2 x14_n2 0 4.077950e-16
C14_n3 x14_n3 0 8.358930e-16
C14_n4 x14_n4 0 1.136930e-15
C14_n5 x14_n5 0 6.754620e-16
C14_n6 x14_n6 0 1.638370e-15
C14_n7 x14_n7 0 1.658580e-16
C14_n8 x14_n8 0 1.639940e-16
C14_n9 x14_n9 0 3.988150e-16
C14_n10 x14_n10 0 3.458080e-16
C14_n11 x14_n11 0 5.791260e-16
C14_n12 x14_n12 0 7.033140e-16
C14_n13 x14_n13 0 1.280110e-16
C14_n14 x14_n14 0 8.372260e-16
C14_n15 x14_n15 0 6.421850e-16
C14_n16 x14_n16 0 6.251960e-16
C14_n17 x14_n17 0 2.887680e-16
C14_n18 x14_n18 0 3.912730e-16
C14_n19 x14_n19 0 2.767240e-16
C14_n20 x14_n20 0 3.627500e-16
C14_n21 x14_n21 0 7.000750e-16
C14_n22 x14_n22 0 3.946960e-16
C14_n23 x14_n23 0 4.295590e-16
C14_n24 x14_n24 0 5.807850e-16
C14_n25 x14_n25 0 1.183940e-15
C14_n26 x14_n26 0 3.925030e-16
C14_n27 x14_n27 0 4.529870e-16
C14_n28 x14_n28 0 2.333970e-16
C14_n29 x14_n29 0 8.241150e-16
C14_n30 x14_n30 0 8.175830e-16
C14_out x14_out 0 5.155240e-15
* --- RO 15 ---
X15_nand EN x15_n30 0 0 VPWR VPWR x15_n0 sky130_fd_sc_hd__nand2_1
X15_inv1 x15_n0 0 0 VPWR VPWR x15_n1 sky130_fd_sc_hd__inv_1
X15_inv2 x15_n1 0 0 VPWR VPWR x15_n2 sky130_fd_sc_hd__inv_1
X15_inv3 x15_n2 0 0 VPWR VPWR x15_n3 sky130_fd_sc_hd__inv_1
X15_inv4 x15_n3 0 0 VPWR VPWR x15_n4 sky130_fd_sc_hd__inv_1
X15_inv5 x15_n4 0 0 VPWR VPWR x15_n5 sky130_fd_sc_hd__inv_1
X15_inv6 x15_n5 0 0 VPWR VPWR x15_n6 sky130_fd_sc_hd__inv_1
X15_inv7 x15_n6 0 0 VPWR VPWR x15_n7 sky130_fd_sc_hd__inv_1
X15_inv8 x15_n7 0 0 VPWR VPWR x15_n8 sky130_fd_sc_hd__inv_1
X15_inv9 x15_n8 0 0 VPWR VPWR x15_n9 sky130_fd_sc_hd__inv_1
X15_inv10 x15_n9 0 0 VPWR VPWR x15_n10 sky130_fd_sc_hd__inv_1
X15_inv11 x15_n10 0 0 VPWR VPWR x15_n11 sky130_fd_sc_hd__inv_1
X15_inv12 x15_n11 0 0 VPWR VPWR x15_n12 sky130_fd_sc_hd__inv_1
X15_inv13 x15_n12 0 0 VPWR VPWR x15_n13 sky130_fd_sc_hd__inv_1
X15_inv14 x15_n13 0 0 VPWR VPWR x15_n14 sky130_fd_sc_hd__inv_1
X15_inv15 x15_n14 0 0 VPWR VPWR x15_n15 sky130_fd_sc_hd__inv_1
X15_inv16 x15_n15 0 0 VPWR VPWR x15_n16 sky130_fd_sc_hd__inv_1
X15_inv17 x15_n16 0 0 VPWR VPWR x15_n17 sky130_fd_sc_hd__inv_1
X15_inv18 x15_n17 0 0 VPWR VPWR x15_n18 sky130_fd_sc_hd__inv_1
X15_inv19 x15_n18 0 0 VPWR VPWR x15_n19 sky130_fd_sc_hd__inv_1
X15_inv20 x15_n19 0 0 VPWR VPWR x15_n20 sky130_fd_sc_hd__inv_1
X15_inv21 x15_n20 0 0 VPWR VPWR x15_n21 sky130_fd_sc_hd__inv_1
X15_inv22 x15_n21 0 0 VPWR VPWR x15_n22 sky130_fd_sc_hd__inv_1
X15_inv23 x15_n22 0 0 VPWR VPWR x15_n23 sky130_fd_sc_hd__inv_1
X15_inv24 x15_n23 0 0 VPWR VPWR x15_n24 sky130_fd_sc_hd__inv_1
X15_inv25 x15_n24 0 0 VPWR VPWR x15_n25 sky130_fd_sc_hd__inv_1
X15_inv26 x15_n25 0 0 VPWR VPWR x15_n26 sky130_fd_sc_hd__inv_1
X15_inv27 x15_n26 0 0 VPWR VPWR x15_n27 sky130_fd_sc_hd__inv_1
X15_inv28 x15_n27 0 0 VPWR VPWR x15_n28 sky130_fd_sc_hd__inv_1
X15_inv29 x15_n28 0 0 VPWR VPWR x15_n29 sky130_fd_sc_hd__inv_1
X15_inv30 x15_n29 0 0 VPWR VPWR x15_n30 sky130_fd_sc_hd__inv_1
X15_buf x15_n15 0 0 VPWR VPWR x15_out sky130_fd_sc_hd__buf_1
C15_n0 x15_n0 0 2.570040e-16
C15_n1 x15_n1 0 1.747980e-16
C15_n2 x15_n2 0 7.626230e-16
C15_n3 x15_n3 0 2.446610e-16
C15_n4 x15_n4 0 1.507620e-16
C15_n5 x15_n5 0 1.370650e-16
C15_n6 x15_n6 0 7.744340e-16
C15_n7 x15_n7 0 1.095470e-15
C15_n8 x15_n8 0 6.937550e-16
C15_n9 x15_n9 0 3.854630e-16
C15_n10 x15_n10 0 3.487740e-16
C15_n11 x15_n11 0 3.881820e-16
C15_n12 x15_n12 0 3.372910e-16
C15_n13 x15_n13 0 4.231600e-16
C15_n14 x15_n14 0 3.621160e-16
C15_n15 x15_n15 0 9.550440e-16
C15_n16 x15_n16 0 1.628300e-16
C15_n17 x15_n17 0 2.373590e-16
C15_n18 x15_n18 0 7.258800e-16
C15_n19 x15_n19 0 2.400890e-16
C15_n20 x15_n20 0 1.845460e-16
C15_n21 x15_n21 0 1.396750e-16
C15_n22 x15_n22 0 6.282940e-16
C15_n23 x15_n23 0 5.475490e-16
C15_n24 x15_n24 0 9.567290e-16
C15_n25 x15_n25 0 5.504410e-16
C15_n26 x15_n26 0 6.421590e-16
C15_n27 x15_n27 0 5.829450e-16
C15_n28 x15_n28 0 3.734090e-16
C15_n29 x15_n29 0 4.239820e-16
C15_n30 x15_n30 0 1.848540e-15
C15_out x15_out 0 4.877130e-15

.save v(x0_out) v(x1_out) v(x2_out) v(x3_out) v(x4_out) v(x5_out) v(x6_out) v(x7_out) v(x8_out) v(x9_out) v(x10_out) v(x11_out) v(x12_out) v(x13_out) v(x14_out) v(x15_out)
.tran 5p 80n
.control
run
meas tran tp0 TRIG v(x0_out) VAL=0.975 RISE=5 TARG v(x0_out) VAL=0.975 RISE=25
meas tran tp1 TRIG v(x1_out) VAL=0.975 RISE=5 TARG v(x1_out) VAL=0.975 RISE=25
meas tran tp2 TRIG v(x2_out) VAL=0.975 RISE=5 TARG v(x2_out) VAL=0.975 RISE=25
meas tran tp3 TRIG v(x3_out) VAL=0.975 RISE=5 TARG v(x3_out) VAL=0.975 RISE=25
meas tran tp4 TRIG v(x4_out) VAL=0.975 RISE=5 TARG v(x4_out) VAL=0.975 RISE=25
meas tran tp5 TRIG v(x5_out) VAL=0.975 RISE=5 TARG v(x5_out) VAL=0.975 RISE=25
meas tran tp6 TRIG v(x6_out) VAL=0.975 RISE=5 TARG v(x6_out) VAL=0.975 RISE=25
meas tran tp7 TRIG v(x7_out) VAL=0.975 RISE=5 TARG v(x7_out) VAL=0.975 RISE=25
meas tran tp8 TRIG v(x8_out) VAL=0.975 RISE=5 TARG v(x8_out) VAL=0.975 RISE=25
meas tran tp9 TRIG v(x9_out) VAL=0.975 RISE=5 TARG v(x9_out) VAL=0.975 RISE=25
meas tran tp10 TRIG v(x10_out) VAL=0.975 RISE=5 TARG v(x10_out) VAL=0.975 RISE=25
meas tran tp11 TRIG v(x11_out) VAL=0.975 RISE=5 TARG v(x11_out) VAL=0.975 RISE=25
meas tran tp12 TRIG v(x12_out) VAL=0.975 RISE=5 TARG v(x12_out) VAL=0.975 RISE=25
meas tran tp13 TRIG v(x13_out) VAL=0.975 RISE=5 TARG v(x13_out) VAL=0.975 RISE=25
meas tran tp14 TRIG v(x14_out) VAL=0.975 RISE=5 TARG v(x14_out) VAL=0.975 RISE=25
meas tran tp15 TRIG v(x15_out) VAL=0.975 RISE=5 TARG v(x15_out) VAL=0.975 RISE=25
let f0 = 20 / tp0
let f1 = 20 / tp1
let f2 = 20 / tp2
let f3 = 20 / tp3
let f4 = 20 / tp4
let f5 = 20 / tp5
let f6 = 20 / tp6
let f7 = 20 / tp7
let f8 = 20 / tp8
let f9 = 20 / tp9
let f10 = 20 / tp10
let f11 = 20 / tp11
let f12 = 20 / tp12
let f13 = 20 / tp13
let f14 = 20 / tp14
let f15 = 20 / tp15
print f0
print f1
print f2
print f3
print f4
print f5
print f6
print f7
print f8
print f9
print f10
print f11
print f12
print f13
print f14
print f15
.endc
.end
